procedure(m2FixFinger(base out)
 let((f pin pins number name newpad result)
  unless(equal(axlDesignType(t) "PACKAGE") error("Not package editor\n"))
  axlSetVariable("padpath" list(strcat(base "/candidate/pads") "D:/001DIY/005lib/01Pad_lib"))
  f=outfile(strcat(out "/changes.txt"))
  pins=axlDBGetDesign()->pins
  unless(equal(length(pins) 67) error("Expected 67 electrical fingers\n"))
  foreach(pin pins
   number=atoi(pin->number)
   name=if(mod(number 2)==1 then "md2_finger_top035x150" else "md2_finger_bottom035x200")
   newpad=axlLoadPadstack(name)
   unless(newpad error("New finger pad could not load\n"))
   fprintf(f "%s\t%L\t%L\t%s\n" pin->number pin->xy pin->name name)
   result=axlReplacePadstack(pin newpad)
   unless(equal(length(result) 1) error("Pad replacement failed\n")))
  unless(axlSaveDesign(?design strcat(base "/candidate/psm/md2_key_m_Finger.dra") ?noMru t ?noConfirm t) error("Save failed\n"))
  unless(axlCompileSymbol(?symbol strcat(base "/candidate/psm/md2_key_m_Finger")) error("Compile failed\n"))
  fprintf(f "FIX_FINGER_COMPLETE\n")
  close(f)
  t))
