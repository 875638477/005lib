procedure(m2Place(base)
 let((row r)
  axlDBChangeDesignUnits("millimeters" 4)
  axlDBChangeDesignExtents(list(-100:-100 100:100))
  axlSetVariable("psmpath" list("D:/001DIY/005lib/01Psm_lib"))
  axlSetVariable("padpath" list("D:/001DIY/005lib/01Pad_lib"))
  foreach(row list(
   list("md2_key_m_Finger" -60:0 nil 0.0)
   list("md2_key_m_Finger" -30:0 nil 90.0)
   list("md2_key_m_Finger" 0:0 t 0.0)
   list("md2_NGFF_M_SMT" -60:50 nil 0.0)
   list("md2_NGFF_M_SMT" -30:50 nil 90.0)
   list("md2_NGFF_M_SMT" 0:50 t 0.0))
   r=axlDBCreateSymbol(list(car(row) "PACKAGE") cadr(row) caddr(row) cadddr(row))
   unless(r error("Compiled PSM failed to place\n")))
  unless(axlSaveDesign(?design strcat(base "/verification/m2_pair_placement.brd") ?noMru t ?noConfirm t) error("Placement save failed\n"))
  t))
procedure(m2PlacedRead(out)
 let((f sym pin layer pad)
  f=outfile(strcat(out "/placed_pins.tsv"))
  fprintf(f "symbol\tsx\tsy\trotation\tmirrored\tpin\tx\ty\tlayer\tfigure\tbbox\n")
  foreach(sym axlDBGetDesign()->symbols
   foreach(pin sym->pins
    foreach(layer list("ETCH/TOP" "ETCH/BOTTOM" "PIN/SOLDERMASK_TOP" "PIN/SOLDERMASK_BOTTOM" "PIN/PASTEMASK_TOP" "PIN/PASTEMASK_BOTTOM")
     pad=axlDBGetPad(pin layer "REGULAR")
     fprintf(f "%s\t%L\t%L\t%L\t%L\t%s\t%L\t%L\t%s\t%L\t%L\n" sym->name car(sym->xy) cadr(sym->xy) sym->rotation sym->isMirrored pin->number car(pin->xy) cadr(pin->xy) layer if(pad then pad->figureName else nil) if(pad then pad->bBox else nil)))))
  close(f)
  t))
