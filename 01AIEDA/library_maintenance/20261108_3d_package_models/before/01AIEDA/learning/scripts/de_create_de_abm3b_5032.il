procedure(deCustomCreate()
let((pad result style bound f)
unless(equal(axlDesignType(t) "PACKAGE") error("Not a package\n"))
unless(length(axlDBGetDesign()->pins)==0 error("Not empty\n"))
axlDBChangeDesignUnits("millimeters" 3)
axlDBChangeDesignExtents(list(-15:-15 15:15))
axlSetVariable("psmpath" list("D:/001DIY/005lib/01AIEDA/learning/examples/de_15_26_20261019/library"))
axlSetVariable("padpath" list("D:/001DIY/005lib/01AIEDA/learning/examples/de_15_26_20261019/library"))
style=make_axlTextOrientation(?textBlock "1" ?rotation 0 ?mirrored nil ?justify "center")
pad=axlLoadPadstack("de_smd180x120")
unless(pad error("Cannot load pad\n"))
result=axlDBCreatePin(pad -2:-1.2 make_axlPinText(?number "1" ?offset 0:0 ?text style) 0.0)
unless(result error("Cannot create pin\n"))
pad=axlLoadPadstack("de_smd180x120")
unless(pad error("Cannot load pad\n"))
result=axlDBCreatePin(pad 2:-1.2 make_axlPinText(?number "2" ?offset 0:0 ?text style) 0.0)
unless(result error("Cannot create pin\n"))
pad=axlLoadPadstack("de_smd180x120")
unless(pad error("Cannot load pad\n"))
result=axlDBCreatePin(pad 2:1.2 make_axlPinText(?number "3" ?offset 0:0 ?text style) 0.0)
unless(result error("Cannot create pin\n"))
pad=axlLoadPadstack("de_smd180x120")
unless(pad error("Cannot load pad\n"))
result=axlDBCreatePin(pad -2:1.2 make_axlPinText(?number "4" ?offset 0:0 ?text style) 0.0)
unless(result error("Cannot create pin\n"))
unless(axlDBCreateLine(list(-2.5:-1.6 2.5:-1.6 2.5:1.6 -2.5:1.6 -2.5:-1.6) 0.05 "PACKAGE GEOMETRY/ASSEMBLY_TOP" nil nil) error("Assembly failed\n"))
result=axlDBCreateRectangle(list(-3.2:-2.05 3.2:2.05) t "PACKAGE GEOMETRY/PLACE_BOUND_TOP" nil nil)
unless(result error("Bound failed\n"))
bound=car(result)
unless(axlDBAddProp(list(bound) list("PACKAGE_HEIGHT_MAX" "1.1 MM")) error("Height failed\n"))
unless(axlDBCreateLine(list(-0.8:1.9 0.8:1.9) 0.12 "PACKAGE GEOMETRY/SILKSCREEN_TOP" nil nil) error("Silk failed\n"))
unless(axlDBCreateLine(list(-0.8:-1.9 0.8:-1.9) 0.12 "PACKAGE GEOMETRY/SILKSCREEN_TOP" nil nil) error("Silk failed\n"))
unless(axlDBCreateLine(list(-3.1:-1.9 -3.1:-2.1 -2.9:-2.1) 0.12 "PACKAGE GEOMETRY/SILKSCREEN_TOP" nil nil) error("Pin1 marker failed\n"))
unless(axlDBCreateText("X*" 0:0 style "REF DES/ASSEMBLY_TOP" nil) error("Refdes failed\n"))
unless(axlSaveDesign(?design "D:/001DIY/005lib/01AIEDA/learning/examples/de_15_26_20261019/library/de_abm3b_5032.dra" ?noMru t ?noConfirm t) error("Save failed\n"))
unless(axlCompileSymbol(?symbol "D:/001DIY/005lib/01AIEDA/learning/examples/de_15_26_20261019/library/de_abm3b_5032") error("Compile failed\n"))
f=outfile("D:/001DIY/005lib/01AIEDA/learning/staging/de_15_26_20261019/create_de_abm3b_5032/create.txt")
fprintf(f "DE_CUSTOM_CREATE_COMPLETE de_abm3b_5032\n")
close(f)
t))
