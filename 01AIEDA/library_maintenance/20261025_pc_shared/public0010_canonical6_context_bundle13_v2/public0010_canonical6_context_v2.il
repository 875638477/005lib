load("D:/001DIY/004computer/lga1700/13shared_libraries_pc_20261025/w/pcb_migration/pc13_export_board_definitions.il")
load("D:/001DIY/004computer/lga1700/cadence_geometry_merge_20261025/psm_export.il")

procedure(pub0010FontContextSnapshot(path)
 let((f n rows p)
  f=outfile(path) n=axlDBGetTextBlockCount() rows=nil
  for(i 1 n p=axlGetParam(sprintf(nil "paramTextBlock:%d" i)) unless(p error("Canonical6 context has missing textblock\n")) rows=cons(list(i p->??) rows) fprintf(f "%L\n" list(i p->??))) close(f) reverse(rows)))
procedure(pub0010Canonical6Context(dir)
 let((jobs beforeUnits beforeFonts afterFonts name alias original fresh beforeDefs exported f d loaded freshDefs)
  sstatus(fullPrecision t) beforeUnits=axlDBGetDesignUnits()
  unless(equal(beforeUnits '("millimeters" 4)) error("Canonical6 must use actual0010 original mm4 context\n"))
  beforeFonts=pub0010FontContextSnapshot(strcat(dir "/SOURCE_ALL_TEXTBLOCKS_BEFORE.ilist")) beforeDefs=length(axlDBGetDesign()->symdefs)
  jobs='(("c0603_pc" "p0010_cold_c0603_pc")
("c0805_pc" "p0010_cold_c0805_pc")
("c1206_pc" "p0010_cold_c1206_pc")
("r0603_pc" "p0010_cold_r0603_pc")
("fb0805_pc" "p0010_cold_fb0805_pc")
("l0805_pc" "p0010_cold_l0805_pc")) exported=0 freshDefs=nil
  axlSetVariable("psmpath" "D:/001DIY/005lib/01AIEDA/library_maintenance/20261025_pc_shared/public0010_canonical6_context_bundle13_v1/aliases D:/001DIY/005lib/01Psm_lib") axlSetVariable("padpath" "D:/001DIY/005lib/01Pad_lib")
  f=outfile(strcat(dir "/PACKAGE_SOURCE_AND_UNIQUE_ALIAS_MANIFEST.tsv")) fprintf(f "canonical\talias\tsourcecachefile\tpublicaliasfile\n")
  foreach(job jobs
   name=car(job) alias=cadr(job)
   axlDBRefreshId(nil)
   original=car(setof(q axlDBGetDesign()->symdefs equal(upperCase(q->name) upperCase(name))))
   unless(original && null(setof(q axlDBGetDesign()->symdefs equal(upperCase(q->name) upperCase(alias)))) error("Canonical6 source missing or alias already cached\n"))
   pc13ExportOneDefinition(original strcat(dir "/actual_" name ".sexp"))
   loaded=axlDBCreateSymbol(list(alias "PACKAGE") '(0.0 0.0))
   unless(loaded && car(loaded) error("Canonical6 public alias package load failed\n"))
   fresh=car(loaded)->definition
   unless(fresh && fresh!=original && !member(fresh freshDefs) && equal(upperCase(fresh->name) upperCase(alias)) error("Canonical6 returned-object package cache miss not forced\n"))
   freshDefs=cons(fresh freshDefs)
   pc13ExportOneDefinition(fresh strcat(dir "/public_" name ".sexp"))
   axlDBRefreshId(nil)
   fprintf(f "%s\t%s\t%s\t%s\n" name alias strcat(dir "/actual_" name ".sexp") strcat(dir "/public_" name ".sexp")) drain(f) exported=exported+1)
  close(f) afterFonts=pub0010FontContextSnapshot(strcat(dir "/SOURCE_ALL_TEXTBLOCKS_AFTER.ilist"))
  unless(equal(beforeUnits axlDBGetDesignUnits()) && equal(beforeFonts afterFonts) && exported==6 && length(freshDefs)==6 error("Canonical6 changed source unit/font context or reused package cache\n"))
  f=outfile(strcat(dir "/CANONICAL6_CONTEXT_COMPLETE.txt")) fprintf(f "SIX_PUBLIC_PACKAGE_BYTE_ALIASES_LOADED_FRESH_IN_ACTUAL0010_MM4_10L_SOURCE_FONTS_CONTEXT\nNO_BOARD_SAVE_NO_PUBLIC_WRITES\nEXISTING_PAD_CACHE_REUSE_EXPLICIT_REQUIRES_FULL_PUBLIC_PAD_MANUFACTURING_XML_PROOF\n") close(f) t))
