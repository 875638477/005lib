; Supplementary read-only adjacency for eight restored U5 Cu bridges.
; Used with all964 direct adjacency; no creation and no save.
load("D:/001DIY/004computer/lga1700/13shared_libraries_pc_20261025/w/pcb_migration/all81_migration_v7/all81_adjacency_probe.il")
procedure(pc13PostSourceCuIndirectTarget(dir)
 let((f plan rows row selections c p n q)
  sstatus(fullPrecision t)
  plan=infile("D:/001DIY/004computer/lga1700/13shared_libraries_pc_20261025/w/pcb_migration/all81_migration_v7/REMAINING50_PHYSICAL_PINS964.ilist")
  rows=nil while(row=lineread(plan) rows=cons(car(row) rows)) close(plan)
  selections=setof(item rows equal(car(item) "U5") && member(cadr(item) '("1" "3" "8" "9" "16" "17" "25" "32")))
  unless(length(selections)==8 error("Exact eight restored source-Cu U5 pin selections missing\n"))
  f=outfile(strcat(dir "/ALL81_POST_SOURCE_CU_TARGET8.ilist"))
  foreach(selection selections
   c=pc13DiagRef(car(selection))
   p=car(setof(x c->symbol->pins equal(x->number cadr(selection)) && equal(x->xy nth(3 selection))))
   unless(p error("Post-sourceCu target pin missing\n"))
   fprintf(f "BEGIN_PIN %L\n" selection) pc13DiagRow(f "TARGET" p)
   foreach(n axlDBGetConnect(p t)
    when(equal(n->objType "shape") && equal(n->net->name p->net->name)
     pc13DiagRow(f "DIRECT_RESTORED_CU_SHAPE" n)
     fprintf(f "RESTORED_SHAPE_PROPERTIES %L\n" n->??)
     foreach(q axlDBGetConnect(n t)
      when(member(q->objType '("path" "cline" "line" "arc")) && equal(q->net->name p->net->name)
       pc13DiagRow(f "INDIRECT_SOURCE_PATH" q)
       foreach(seg q->segments pc13DiagRow(f "INDIRECT_PATH_SEGMENT" seg))))))
   fprintf(f "END_PIN %L\n" selection) drain(f))
  fprintf(f "ALL81_POST_SOURCE_CU_TARGET8_COMPLETE\n") close(f) t))
