; Read only original source06B8 or49AF. Prove pre-existing positive Cu touch.
load("D:/001DIY/004computer/lga1700/13shared_libraries_pc_20261025/w/pcb_migration/all81_source_cu_v5/all81_restore_actual_source_cu_v5.il")
procedure(pc13VddOriginalTouchProof(dir)
 let((p short paths ps shortCu other otherCu overlap pinCu pinTouch f pf)
  sstatus(fullPrecision t)
  p=car(setof(q pc13Comp("U5")->symbol->pins equal(q->number "3")))
  unless(p && equal(p->xy 678.6:521.8) && equal(p->net->name "VDD10_1") && equal(p->name "SMD_R90X300P0S20") error("Frozen source U5.3 identity/net/pad mismatch\n"))
  pc13CuStepPort=outfile(strcat(dir "/VDD_SOURCE_TOUCH_STEP.txt")) pc13BuildCuIndex("SOURCE_VDD_TOUCH")
  short=nil paths=nil
  foreach(index pc13CuIndexRows
   when(equal(nth(4 index) "path") && equal(nth(1 index) "VDD10_1") && equal(nth(2 index) "ETCH/TOP")
    when(car(setof(seg car(index)->segments equal(seg->objType "line") && equal(seg->width 8.0) && equal(pc13SourceCuKey("line" "VDD10_1" "ETCH/TOP" 8.0 seg->startEnd) "(\"line\" \"VDD10_1\" \"ETCH/TOP\" 8.0 (67860 52180) (67860 55860))")))
     short=cons(index short))))
  unless(length(short)==1 && caar(short)->nSegs==1 error("Exact original8mil VDD source path missing\n")) short=car(short)
  shortCu=pc13IndexedCuPolys(short "ETCH/TOP")
  foreach(index pc13CuIndexRows
   when(equal(nth(4 index) "path") && equal(nth(1 index) "VDD10_1") && equal(nth(2 index) "ETCH/TOP") && !equal(car(index) car(short))
    when(pc13BoxesMeet(nth(3 index) nth(3 short))
     ps=pc13IndexedCuPolys(index "ETCH/TOP")
     when(pc13RingOp(shortCu ps 'AND) paths=cons(list(index ps) paths)))))
  unless(length(paths)==1 error("Expected exactly one original same-net path physically touching source8mil line\n"))
  other=caar(paths) otherCu=cadar(paths)
  unless(car(other)->nSegs==2 error("Original other VDD source path segment count differs\n"))
  foreach(seg car(other)->segments unless(equal(seg->objType "line") && equal(seg->width 15.0) error("Other original VDD path is not actual15mil line\n")))
  overlap=pc13RingOp(shortCu otherCu 'AND)
  unless(overlap && car(overlap)->area>0 error("Original VDD paths lack positive physical Cu touch\n"))
  pinCu=axlPolyFromDB(p ?layer "ETCH/TOP" ?padType 'REGULAR ?holes t) when(axlPolyErrorGet() error("Source pin3 Cu conversion failed\n")) pinCu=remove(nil pinCu)
  pinTouch=pc13RingOp(pinCu shortCu 'AND)
  unless(pinTouch && car(pinTouch)->area>0 error("Original source pin3 lacks positive physical Cu contact to its8mil path\n"))
  f=outfile(strcat(dir "/VDD_SOURCE_ACTUAL_TOUCH.ilist"))
  fprintf(f "SOURCE_PIN3 %L\nSOURCE_PIN3_NATIVE_NEIGHBORS %L\nSOURCE_SHORT_PATH %L\nSOURCE_SHORT_NATIVE_CONNECTIONS %L\nSOURCE_OTHER_PATH %L\nSOURCE_OTHER_NATIVE_CONNECTIONS %L\n" p->?? axlDBGetConnect(p t) car(short)->?? axlDBGetConnect(car(short) t) car(other)->?? axlDBGetConnect(car(other) t))
  foreach(seg car(short)->segments fprintf(f "SOURCE_SHORT_SEGMENT %L\n" seg->??))
  foreach(seg car(other)->segments fprintf(f "SOURCE_OTHER_SEGMENT %L\n" seg->??)) close(f)
  pf=outfile(strcat(dir "/VDD_SOURCE_ACTUAL_TOUCH.jsonl"))
  pc13RingWrite(pf "U5.3" "ORIGINAL_ACTUAL_TOP_PIN_CU" pinCu)
  pc13RingWrite(pf "U5.3" "ORIGINAL_8MIL_PATH_CU" shortCu)
  pc13RingWrite(pf "VDD10_1" "ORIGINAL_OTHER_15MIL_PATH_CU" otherCu)
  pc13RingWrite(pf "U5.3" "SOURCE_PIN_AND_SHORT_PATH_POSITIVE_TOUCH" pinTouch)
  pc13RingWrite(pf "VDD10_1" "ORIGINAL_TWO_PATHS_ALREADY_POSITIVE_CU_TOUCH" overlap) close(pf)
  f=outfile(strcat(dir "/VDD_ORIGINAL_TOUCH_COMPLETE.txt")) fprintf(f "SOURCE_PIN3_LOGICAL_NET=VDD10_1\nSOURCE_PIN3_TO8MIL_CU_POSITIVE_AND\nSOURCE8MIL_TO_OTHER15MIL_CU_POSITIVE_AND\nREAD_ONLY_NO_CREATE_NO_SAVE\n") close(f)
  close(pc13CuStepPort) t))
