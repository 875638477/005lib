; Owned candidate copy only. Full source constraints restored, no broad replace flags.
load("D:/001DIY/004computer/lga1700/12electrical_fixed_20261025/rules/replay/native_constraints_helpers.il")
procedure(pub14RestoreCompleteSourceRules(dir)
 let((f d c byref row rows result tc dc outdc outtc exitCode props)
  f=outfile(strcat(dir "/EXACT_SOURCE_RULE_RESTORE.txt"))
  fprintf(f "BOARD=00012 806247E3852D014713886B4BDFD72C049A682FED3821EAEBDC41F1CE3B0A3E2E256=806247E3852D014713886B4BDFD72C049A682FED3821EAEBDC41F1CE3B0A3E2E\n")
  rows=list(list("C408" "CAP_0805_1UF" "C0805_PC" "YES") list("C388" "CAP_0805_1UF" "C0805_PC" "YES") list("C389" "CAP_0805_1UF" "C0805_PC" "YES") list("C128" "CAP_0805_1UF" "C0805_PC" "YES") list("C133" "CAP_0805_1UF" "C0805_PC" "YES") list("C108" "CAP_0805_1UF" "C0805_PC" "YES") list("C127" "CAP_0805_1UF" "C0805_PC" "YES") list("C132" "CAP_0805_1UF" "C0805_PC" "YES") list("C104" "CAP_0805_1UF" "C0805_PC" "YES") list("C40" "CAP_0805_1UF" "C0805_PC" "YES") list("C210" "CAP_0805_1UF" "C0805_PC" "YES") list("C36" "CAP_0805_1UF" "C0805_PC" "YES") list("C38" "CAP_0805_1UF" "C0805_PC" "YES") list("C185" "CAP_0805_1UF" "C0805_PC" "YES") list("C184" "CAP_0805_1UF" "C0805_PC" "YES") list("C79" "CAP_0805_1UF" "C0805_PC" "YES") list("C74" "CAP_0805_1UF" "C0805_PC" "YES") list("C44" "CAP_0603_0.1UF (25V)" "C0603_PC" "YES") list("C221" "CAP_0603_0.001UF" "C0603_PC" "16V") list("C373" "CAP_0603_0.001UF" "C0603_PC" "16V") list("C366" "CAP_0603_0.001UF" "C0603_PC" "16V") list("C52" "CAP_0603_0.001UF" "C0603_PC" "16V") list("C59" "CAP_0603_0.001UF" "C0603_PC" "16V") list("C92" "CAP_0603_0.001UF" "C0603_PC" "16V") list("C72" "CAP_0603_0.001UF" "C0603_PC" "16V") list("C97" "CAP_0603_0.001UF" "C0603_PC" "16V") list("C63" "CAP_0603_0.001UF" "C0603_PC" "16V") list("C137" "CAP_0603_0.001UF" "C0603_PC" "16V") list("C164" "CAP_0603_0.001UF" "C0603_PC" "16V") list("C109" "CAP_0603_0.001UF" "C0603_PC" "16V") list("C161" "CAP_0603_0.001UF" "C0603_PC" "16V") list("C88" "CAP_0402_0.1UF" "C0402_PC" "16V") list("C70" "CAP_0402_0.1UF" "C0402_PC" "16V") list("C94" "CAP_0402_0.1UF" "C0402_PC" "16V") list("C60" "CAP_0402_0.1UF" "C0402_PC" "16V") list("C136" "CAP_0402_0.01UF" "C0402_PC" "16V") list("C139" "CAP_0402_0.01UF" "C0402_PC" "16V") list("C367" "CAP_0402_0.01UF" "C0402_PC" "16V") list("C89" "CAP_0402_0.01UF" "C0402_PC" "16V") list("C71" "CAP_0402_0.01UF" "C0402_PC" "16V") list("C95" "CAP_0402_0.01UF" "C0402_PC" "16V") list("C61" "CAP_0402_0.01UF" "C0402_PC" "16V") list("C386" "CAP_0402_0.01UF" "C0402_PC" "16V") list("C166" "CAP_0402_0.01UF" "C0402_PC" "16V") list("C102" "CAP_0402_0.01UF" "C0402_PC" "16V") list("C405" "CAP_0402_0.01UF" "C0402_PC" "16V") list("C106" "CAP_0805_2.2UF" "C0805_PC" "6.3V") list("C107" "CAP_0805_2.2UF" "C0805_PC" "6.3V") list("C67" "CAP_0805_2.2UF" "C0805_PC" "6.3V") list("C100" "CAP_0805_2.2UF" "C0805_PC" "6.3V") list("C110" "CAP_0805_2.2UF" "C0805_PC" "6.3V") list("C62" "CAP_0805_2.2UF" "C0805_PC" "6.3V") list("C80" "CAP_0805_2.2UF" "C0805_PC" "6.3V") list("C75" "CAP_0805_2.2UF" "C0805_PC" "6.3V") list("C56" "CAP_0805_2.2UF" "C0805_PC" "6.3V") list("C43" "CAP_0805_2.2UF" "C0805_PC" "6.3V") list("C47" "CAP_0805_2.2UF" "C0805_PC" "6.3V") list("C68" "CAP_0805_2.2UF" "C0805_PC" "6.3V") list("C51" "CAP_0805_2.2UF" "C0805_PC" "6.3V") list("C76" "CAP_0805_2.2UF" "C0805_PC" "6.3V") list("C81" "CAP_0805_2.2UF" "C0805_PC" "6.3V") list("C41" "CAP_0805_2.2UF" "C0805_PC" "6.3V") list("C42" "CAP_0805_2.2UF" "C0805_PC" "6.3V") list("C209" "CAP_0805_2.2UF" "C0805_PC" "6.3V") list("C192" "CAP_0805_2.2UF" "C0805_PC" "6.3V") list("C362" "CAP_0805_2.2UF" "C0805_PC" "6.3V") list("C254" "CAP_0805_2.2UF" "C0805_PC" "6.3V") list("C77" "CAP_0805_2.2UF" "C0805_PC" "6.3V") list("C64" "CAP_0805_2.2UF" "C0805_PC" "6.3V") list("C82" "CAP_0805_2.2UF" "C0805_PC" "6.3V") list("C53" "CAP_0805_2.2UF" "C0805_PC" "6.3V") list("C87" "CAP_0805_2.2UF" "C0805_PC" "6.3V") list("C69" "CAP_0805_2.2UF" "C0805_PC" "6.3V") list("C54" "CAP_0805_2.2UF" "C0805_PC" "6.3V") list("C93" "CAP_0805_2.2UF" "C0805_PC" "6.3V") list("C83" "CAP_0805_2.2UF" "C0805_PC" "6.3V") list("C165" "CAP_0402_DNI" "C0402_PC" "16V") list("C163" "CAP_0402_DNI" "C0402_PC" "16V") list("C407" "CAP_0805_DNI" "C0805_PC" "YES"))
  when(rows
   d=axlDBGetDesign() byref=makeTable('pub14RestorePropertyRef nil)
   foreach(c d->components byref[c->name]=c)
   foreach(row rows
    c=byref[car(row)] unless(c && equal(c->deviceType cadr(row)) && equal(c->package caddr(row)) error("Exact source customprop reference failed\n"))
    axlDBRefreshId(c) props=axlDBGetProperties(c '("user" "allegro")) unless(equal(props nil) error("Source lost customprop nil precondition failed\n"))
    result=axlDBAddProp(list(c) list("VOLTAGE" nth(3 row)))
    axlDBRefreshId(c) props=axlDBGetProperties(c '("user" "allegro"))
    fprintf(f "RESTORE_PROP_REF=%L RESULT=%L ACTUAL_PROPERTIES=%L\n" car(row) result props) drain(f)
    unless(equal(props list(list('VOLTAGE nth(3 row)))) error("Exact source customprop immediate readback failed\n"))))
  fprintf(f "CMXL_INIT=%L\n" axlCMDBInit())
  d=cmxlFindObject(REDS_DESIGN_OBJ) unless(d error("CMXL active design missing\n"))
  fprintf(f "CMXL_SKILL_INIT=%L\n" cmxlDBSkillInit(d))
  tc=cmxlImportFile(d "D:/001DIY/005lib/01AIEDA/library_maintenance/20261025_pc_shared/module_source_constraint_restore15_v2/00012/EXACT_SOURCE_REMAPPED.tcfx") fprintf(f "COMPLETE_SOURCE_TCFX_IMPORT=%L\n" tc) drain(f)
  dc=cmxlImportFile(d "D:/001DIY/005lib/01AIEDA/library_maintenance/20261025_pc_shared/module_source_constraint_restore15_v2/00012/EXACT_SOURCE_REMAPPED.dcfx") fprintf(f "COMPLETE_SOURCE_DCFX_IMPORT=%L\n" dc) drain(f)
  outdc=cmxlExportFile(d strcat(dir "/IMMEDIATE_SOURCE_RESTORED.dcfx"))
  outtc=cmxlExportFile(d strcat(dir "/IMMEDIATE_SOURCE_RESTORED.tcfx"))
  exitCode=axlCMDBExit()
  fprintf(f "IMMEDIATE_DCFX=%L\nIMMEDIATE_TCFX=%L\nCMXL_EXIT=%L\n" outdc outtc exitCode) close(f)
  unless(tc==1 && dc==1 && outdc==1 && outtc==1 && exitCode==0 error("Exact source CFX/TCFX restore native import/export failed\n"))
  unless(axlSaveDesign(?design strcat(dir "/SOURCE_RULES_RESTORED.brd") ?noMru t ?noConfirm t) error("Restored source-rules candidate save failed\n"))
  f=outfile(strcat(dir "/EXACT_SOURCE_RULE_RESTORE_COMPLETE.txt")) fprintf(f "COMPLETE_NATIVE_SOURCE_RULE_RESTORE_STAGING_ONLY_FRESH_FULL_READBACK_REQUIRED\n") close(f) t))
