; Owned candidate copy only. Full source constraints restored, no broad replace flags.
load("D:/001DIY/004computer/lga1700/12electrical_fixed_20261025/rules/replay/native_constraints_helpers.il")
procedure(pub14RestoreCompleteSourceRules(dir)
 let((f d c byref row rows result tc dc outdc outtc exitCode props)
  f=outfile(strcat(dir "/EXACT_SOURCE_RULE_RESTORE.txt"))
  fprintf(f "BOARD=008 0B836A2E0043FBB7A75A3AFD5282FA356D51449A0478B2DD812EB9E6EC76C01D256=0B836A2E0043FBB7A75A3AFD5282FA356D51449A0478B2DD812EB9E6EC76C01D\n")
  rows=list()
  when(rows
   d=axlDBGetDesign() byref=makeTable('pub14RestorePropertyRef nil)
   foreach(c d->components byref[c->name]=c)
   foreach(row rows
    c=byref[car(row)] unless(c && equal(c->deviceType cadr(row)) && equal(c->package caddr(row)) error("Exact source customprop reference failed\n"))
    axlDBRefreshId(c) props=axlDBGetProperties(c '("user" "allegro")) unless(equal(props nil) error("Source lost customprop nil precondition failed\n"))
    result=axlDBAddProp(list(c) list("VOLTAGE" nth(3 row)))
    axlDBRefreshId(c) props=axlDBGetProperties(c '("user" "allegro"))
    fprintf(f "RESTORE_PROP_REF=%L RESULT=%L ACTUAL_PROPERTIES=%L\n" car(row) result props) drain(f)
    unless(equal(props list(list('VOLTAGE nth(3 row)))) error("Exact source customprop immediate readback failed\n"))))
  fprintf(f "CMXL_INIT=%L\n" axlCMDBInit())
  d=cmxlFindObject(REDS_DESIGN_OBJ) unless(d error("CMXL active design missing\n"))
  fprintf(f "CMXL_SKILL_INIT=%L\n" cmxlDBSkillInit(d))
  tc=cmxlImportFile(d "D:/001DIY/005lib/01AIEDA/library_maintenance/20261025_pc_shared/module_source_constraint_restore15_v2/008/EXACT_SOURCE_REMAPPED.tcfx") fprintf(f "COMPLETE_SOURCE_TCFX_IMPORT=%L\n" tc) drain(f)
  dc=cmxlImportFile(d "D:/001DIY/005lib/01AIEDA/library_maintenance/20261025_pc_shared/module_source_constraint_restore15_v2/008/EXACT_SOURCE_REMAPPED.dcfx") fprintf(f "COMPLETE_SOURCE_DCFX_IMPORT=%L\n" dc) drain(f)
  outdc=cmxlExportFile(d strcat(dir "/IMMEDIATE_SOURCE_RESTORED.dcfx"))
  outtc=cmxlExportFile(d strcat(dir "/IMMEDIATE_SOURCE_RESTORED.tcfx"))
  exitCode=axlCMDBExit()
  fprintf(f "IMMEDIATE_DCFX=%L\nIMMEDIATE_TCFX=%L\nCMXL_EXIT=%L\n" outdc outtc exitCode) close(f)
  unless(tc==1 && dc==1 && outdc==1 && outtc==1 && exitCode==0 error("Exact source CFX/TCFX restore native import/export failed\n"))
  unless(axlSaveDesign(?design strcat(dir "/SOURCE_RULES_RESTORED.brd") ?noMru t ?noConfirm t) error("Restored source-rules candidate save failed\n"))
  f=outfile(strcat(dir "/EXACT_SOURCE_RULE_RESTORE_COMPLETE.txt")) fprintf(f "COMPLETE_NATIVE_SOURCE_RULE_RESTORE_STAGING_ONLY_FRESH_FULL_READBACK_REQUIRED\n") close(f) t))
