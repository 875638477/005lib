load("D:/001DIY/005lib/01AIEDA/library_maintenance/20261025_pc_shared/public0010_route_net_diagnostic_bundle13_v1/public0010_route_net_diagnostic_v1.il")

procedure(pub0010CollectRouteObjects()
 pub0010RouteSeen=makeTable('pub0010RouteSeen nil) pub0010ActualLines=makeTable('pub0010ActualLines nil)
 foreach(n axlDBGetDesign()->nets foreach(b n->branches pub0010RouteObjectsWalk(b)))
 foreach(b axlDBGetLonelyBranches() pub0010RouteObjectsWalk(b)) t)
procedure(pub0010ViaWalk(o)
 let((attrs)
  when(o && !pub0010ViaSeen[o]
   pub0010ViaSeen[o]=t
   when(equal(o->objType "via") pub0010ViaRows=cons(list(o->xy o->name if(o->net then o->net->name else "__NO_NET__") pc13Props(o)) pub0010ViaRows))
   attrs=o->? when(member('children attrs) foreach(x o->children pub0010ViaWalk(x)))
   when(member('segments attrs) foreach(x o->segments pub0010ViaWalk(x))))))
procedure(pub0010ViasSnapshot(path)
 let((rows f)
  pub0010ViaSeen=makeTable('pub0010ViaSeen nil) pub0010ViaRows=nil
  foreach(n axlDBGetDesign()->nets foreach(b n->branches pub0010ViaWalk(b)))
  foreach(b axlDBGetLonelyBranches() pub0010ViaWalk(b))
  rows=sort(foreach(mapcar r pub0010ViaRows sprintf(nil "%L" r)) 'alphalessp)
  unless(length(rows)==1739 error("PUB0010 full1739 via snapshot incomplete\n"))
  f=outfile(path) foreach(r rows fprintf(f "%s\n" r)) close(f) rows))
procedure(pub0010NilSourcePrepare(dir)
 let((rows f key objects o)
  sstatus(fullPrecision t) pub403ReadUnits() pub403FullTypedGate(strcat(pub403Bundle "/SOURCE_FULL2698_WITH_NONLOGICAL_IDENTITIES.ilist"))
  pub403StateGate(strcat(pub403Bundle "/SOURCE_CONTROL_EXPECTED_ALL593_TEXT_PROPS.ilist"))
  pub0010CollectRouteObjects() pub0010OriginalNilProps=makeTable('pub0010OriginalNilProps nil) pub0010NilAllowed=makeTable('pub0010NilAllowed nil)
  rows=pub403Rows("D:/001DIY/005lib/01AIEDA/library_maintenance/20261025_pc_shared/public0010_nil_route_stub_bundle13_v1/EXACT54_SOURCE_LINES_CURRENT_NET_NIL.ilist") unless(length(rows)==54 error("PUB0010 NIL allowance must be exact54 lines\n"))
  f=outfile(strcat(dir "/ORIGINAL54_LINE_AND_PARENT_PROPERTIES.ilist"))
  foreach(row rows
   key=pub0010RouteGeomKey(car(row) nth(2 row) nth(3 row) nth(4 row)) objects=pub0010ActualLines[key]
   unless(length(objects)==1 error("PUB0010 original exact line must have unique native object %L\n" row)) o=car(objects)
   unless(equal(o->net->name nth(1 row)) && equal(o->objType "line") error("PUB0010 frozen original line native source net differs %L\n" row))
   pub0010OriginalNilProps[key]=list(pc13Props(o) pc13Props(o->parent) o->parent->objType)
   pub0010NilAllowed[key]=nth(1 row)
   fprintf(f "%L\n" list(row pub0010OriginalNilProps[key]))) close(f)
  pub0010OriginalVias=pub0010ViasSnapshot(strcat(dir "/ORIGINAL_ALL1739_TYPED_VIAS.ilist")) pub0010OriginalViaNativeRows=pub0010ViaRows
  f=outfile(strcat(dir "/ORIGINAL_NIL_REPAIR_SOURCE_PREPARED.txt")) fprintf(f "ORIGINAL_SOURCE54_EXACT_NATIVE_LINE_AND_PARENT_PROPERTIES_FROZEN\nALL1739_TYPED_VIAS_FROZEN\nNO_SOURCE_MUTATION_OR_SAVE\n") close(f) t))
procedure(pub0010NilTriggerFits(row)
 prog((key objects o source expected path stub actual overlap)
  key=pub0010RouteGeomKey(nth(4 row) nth(3 row) nth(5 row) nth(6 row))
  expected=pub0010NilAllowed[key] unless(expected && equal(expected nth(2 row)) return(nil))
  objects=pub0010ActualLines[key] unless(length(objects)==1 error("PUB0010 allowed NIL exact line no longer unique %L\n" row)) o=car(objects)
  unless(null(o->net->name) return(nil))
  unless(equal(pub0010OriginalNilProps[key] list(pc13Props(o) pc13Props(o->parent) o->parent->objType)) error("PUB0010 allowed NIL original line/parent properties changed %L\n" row))
  path=axlPathStart(list(nth(7 row) nth(8 row)) nth(9 row)) stub=axlPolyFromDB(path ?line2poly t ?endCapType 'ROUND ?holes t)
  when(axlPolyErrorGet() error("PUB0010 NIL attachment stub conversion failed\n")) stub=remove(nil stub)
  actual=axlPolyFromDB(o ?line2poly t ?endCapType 'ROUND ?holes t)
  when(axlPolyErrorGet() error("PUB0010 existing original-NIL actual line conversion failed\n")) actual=remove(nil actual)
  unless(stub && actual error("PUB0010 NIL trigger physical stroke empty\n"))
  overlap=pc13RingOp(stub actual 'AND)
  unless(overlap return(nil)) foreach(p overlap unless(p->area>0.0 return(nil)))
  fprintf(pub0010NilTriggerPort "%L\n" list(row o "EXACT_ORIGINAL_NIL_LINE_PROPERTIES_AND_POSITIVE_AREA_INTERSECTION")) drain(pub0010NilTriggerPort)
  return(t)))
procedure(pub0010NilStubCandidateStatus(row)
 prog((pin matching path polys pad outside)
  pin=pc13SotStubPin(car(row) cadr(row))
  unless(pin && equal(pin->xy nth(8 row)) && equal(pin->net->name nth(2 row)) && equal(pin->name nth(11 row)) return("TARGET_PIN_GUARD_FAILED"))
  matching=setof(x pc13StubSegments equal(car(x) nth(4 row)) && equal(nth(1 x) nth(2 row)) && equal(nth(2 x) nth(3 row)) && equal(nth(3 x) nth(5 row)) && (equal(nth(4 x) nth(6 row)) || equal(nth(4 x) reverse(nth(6 row)))))
  unless(matching || (equal(nth(4 row) "line") && pc13SotLineUnionCovers(row)) || pub0010FrozenStrokeCovered(row) || pub0010NilTriggerFits(row) return("ORIGINAL_SOURCE_STROKE_NOT_IN_CURRENT_SAME_NET_CU"))
  path=axlPathStart(list(nth(7 row) nth(8 row)) nth(9 row))
  polys=axlPolyFromDB(path ?line2poly t ?endCapType 'ROUND ?holes t)
  when(axlPolyErrorGet() return("STUB_STROKE_POLYGON_ERROR")) polys=remove(nil polys)
  unless(polys return("EMPTY_STUB_STROKE"))
  pad=axlPolyFromDB(pin ?layer nth(3 row) ?padType 'REGULAR ?holes t)
  when(axlPolyErrorGet() return("TARGET_REGULAR_PAD_POLYGON_ERROR")) pad=remove(nil pad)
  unless(pad return("EMPTY_TARGET_REGULAR_PAD"))
  outside=pc13RingOp(polys pad 'ANDNOT)
  return(if(outside then "STROKE_OUTSIDE_TARGET_REGULAR_PAD" else "FIT_WHOLE_STROKE_INSIDE_TARGET_REGULAR_PAD"))))

procedure(pub0010NilCreateStubs(rows f)
 let((pin path created count)
  count=0
  foreach(row rows
   pin=pc13SotStubPin(car(row) cadr(row))
   unless(pin && equal(pin->xy nth(8 row)) && equal(pin->net->name nth(2 row)) error("PUB0010 frozen stub target changed before creation\n"))
   path=axlPathStart(list(nth(7 row) nth(8 row)) nth(9 row)) created=axlDBCreatePath(path nth(3 row) nth(2 row))
   unless(created error("PUB0010 exact pad-contained stub creation failed %L\n" row))
   count=count+1 fprintf(f "%L\n" list(row created)) drain(f)) count))
procedure(pub0010NilRouteRepair(dir)
 let((f groups row key objects o expected chosen selectedKeys selections failures statusPort status answer geometryKey tested fits failed frozenCount count beforeVias missing)
  sstatus(fullPrecision t) pub403ReadUnits()
  unless(pub0010OriginalVias && pub0010OriginalNilProps error("PUB0010 original source prepare globals absent\n"))
  pub403FullTypedGate(strcat(pub403Bundle "/TARGET_FULL2698_WITH_NONLOGICAL_IDENTITIES.ilist"))
  pub403StateGate(strcat(pub403Bundle "/SOURCE_CONTROL_EXPECTED_ALL593_TEXT_PROPS.ilist")) pub403AllNameGate(nil)
  pub0010RepairDRC=axlDBControl('drcEnable) pub0010RepairFill=axlDBControl('dynamicFillMode)
  pub0010CollectRouteObjects() rows=pub403Rows("D:/001DIY/005lib/01AIEDA/library_maintenance/20261025_pc_shared/public0010_nil_route_stub_bundle13_v1/EXACT54_SOURCE_LINES_CURRENT_NET_NIL.ilist")
  foreach(row rows
   key=pub0010RouteGeomKey(car(row) nth(2 row) nth(3 row) nth(4 row)) objects=pub0010ActualLines[key]
   unless(length(objects)==1 error("PUB0010 allowed exact54 target line must remain unique\n")) o=car(objects)
   unless(null(o->net->name) && equal(pub0010OriginalNilProps[key] list(pc13Props(o) pc13Props(o->parent) o->parent->objType)) error("PUB0010 target54 must be NIL-only with complete original line/parent properties\n")))
  beforeVias=pub0010ViasSnapshot(strcat(dir "/TARGET_BEFORE_ALL1739_TYPED_VIAS.ilist")) pub0010InputViaNativeRows=pub0010ViaRows pub0010FrozenInputViaGate(beforeVias)
  pc13StubSeen=makeTable('pc13StubSeen nil) pc13StubSegments=nil
  foreach(n axlDBGetDesign()->nets foreach(b n->branches pc13SotStubWalk(b))) foreach(b axlDBGetLonelyBranches() pc13SotStubWalk(b))
  pub0010BuildCuIndex() pub0010FrozenKeys=makeTable('pub0010FrozenKeys nil) pub0010StrokeCached=makeTable('pub0010StrokeCached nil) pub0010StrokeCovered=makeTable('pub0010StrokeCovered nil)
  frozenCount=0 f=infile("D:/001DIY/005lib/01AIEDA/library_maintenance/20261025_pc_shared/public0010_path_stubs_plan13_v1/SOURCE_FROZEN_REAL_SEGMENTS.ilist")
  while(row=lineread(f) row=car(row) frozenCount=frozenCount+1 pub0010FrozenKeys[pub0010SourceKey(car(row) nth(1 row) nth(2 row) nth(3 row) nth(4 row))]=t) close(f)
  unless(frozenCount==2068 error("PUB0010 whole-sourceCu frozen2068 ledger incomplete\n"))
  groups=pub403Rows("D:/001DIY/005lib/01AIEDA/library_maintenance/20261025_pc_shared/public0010_path_stubs_plan13_v1/PUB0010_STUB_CANDIDATES.ilist") unless(length(groups)==877 error("PUB0010 frozen877 source branches incomplete\n"))
  statusPort=outfile(strcat(dir "/BOUNDED_NIL_ALL_BRANCH_CANDIDATE_STATUS.ilist")) pub0010NilTriggerPort=outfile(strcat(dir "/EXACT54_NIL_STROKE_ATTACHMENT_TRIGGERS.ilist"))
  f=outfile(strcat(dir "/PREFLIGHT_FAILED_BRANCH_GROUPS.ilist")) failed=0 fits=0 tested=0 selections=nil selectedKeys=nil
  foreach(group groups
   chosen=nil
   foreach(candidate cadr(group)
    unless(chosen
     answer=errset(pub0010NilStubCandidateStatus(candidate) t) tested=tested+1
     status=if(answer then car(answer) else "NATIVE_ERROR_SEE_STDOUT") fprintf(statusPort "%L\n" list(car(group) status candidate)) drain(statusPort)
     when(equal(status "FIT_WHOLE_STROKE_INSIDE_TARGET_REGULAR_PAD") chosen=candidate)))
   if(chosen then fits=fits+1 geometryKey=list(car(chosen) cadr(chosen) nth(2 chosen) nth(3 chosen) nth(7 chosen) nth(8 chosen) nth(9 chosen))
    unless(member(geometryKey selectedKeys) selectedKeys=cons(geometryKey selectedKeys) selections=cons(chosen selections))
   else failed=failed+1 fprintf(f "%L\n" group) drain(f)))
  close(f) close(statusPort) close(pub0010NilTriggerPort)
  f=outfile(strcat(dir "/BOUNDED_NIL_PREFLIGHT_COMPLETE.txt")) fprintf(f "BRANCHES=877\nFIT=%d\nFAILED=%d\nTESTED=%d\nUNIQUE_STUBS=%d\n" fits failed tested length(selections)) close(f)
  printf("PUB0010_PARTIAL_ALLOWED_UNRESOLVED_BRANCHES=%d_ONLY_NATIVE_PAD_CONTAINED_SELECTIONS_WILL_CREATE\n" failed)
  selections=reverse(selections) f=outfile(strcat(dir "/EXACT_SELECTED_PAD_INTERNAL_STUBS.ilist")) foreach(row selections fprintf(f "%L\n" row)) close(f)
  f=outfile(strcat(dir "/PAD_INTERNAL_STUBS_CREATED.ilist")) count=axlDBCloak('pub0010NilCreateStubs(selections f) 'shape) close(f)
  unless(count==length(selections) error("PUB0010 bounded pad-internal stub creation batch incomplete\n"))
  axlDBRefreshId(nil) pub0010CollectRouteObjects() failures=nil
  f=outfile(strcat(dir "/EXACT54_ORIGINAL_ROUTE_NET_AFTER.ilist"))
  foreach(row rows
   key=pub0010RouteGeomKey(car(row) nth(2 row) nth(3 row) nth(4 row)) objects=pub0010ActualLines[key]
   fprintf(f "%L\n" list(row foreach(mapcar q objects list(q q->net->name pc13Props(q) pc13Props(q->parent)))))
   unless(length(objects)==1 && equal(car(objects)->net->name nth(1 row)) && equal(pub0010OriginalNilProps[key] list(pc13Props(car(objects)) pc13Props(car(objects)->parent) car(objects)->parent->objType)) failures=cons(row failures))) close(f)
  pub0010Unresolved54=failures printf("PUB0010_PARTIAL_ORIGINAL54_POSTCHECK_UNRESOLVED=%d\n" length(failures))
  pub0010ViasSnapshot(strcat(dir "/AFTER_ALL1739_TYPED_VIAS.ilist")) pub0010PartialViaGate(dir)
  pub0010BuildCuIndex() pub0010StrokeCached=makeTable('pub0010StrokeCached nil) pub0010StrokeCovered=makeTable('pub0010StrokeCovered nil)
  f=outfile(strcat(dir "/FULL2068_SOURCE_OWN_NET_CU_COVERAGE.ilist")) missing=nil
  foreach(source pub403Rows("D:/001DIY/005lib/01AIEDA/library_maintenance/20261025_pc_shared/public0010_path_stubs_plan13_v1/SOURCE_FROZEN_REAL_SEGMENTS.ilist")
   row=list("FULL_SOURCE_CU" "" nth(1 source) nth(2 source) car(source) nth(3 source) nth(4 source))
   answer=errset(pub0010FrozenStrokeCovered(row) t)
   unless(answer && car(answer) missing=cons(source missing)) fprintf(f "%L\n" list(source answer)) drain(f)) close(f)
  pub0010MissingCuRows=missing printf("PUB0010_PARTIAL_SOURCE2068_OWN_NET_CU_UNCOVERED=%d\n" length(missing))
  pub403FullTypedGate(strcat(pub403Bundle "/TARGET_FULL2698_WITH_NONLOGICAL_IDENTITIES.ilist"))
  pub403StateGate(strcat(pub403Bundle "/SOURCE_CONTROL_EXPECTED_ALL593_TEXT_PROPS.ilist")) pub403AllNameGate(nil)
  unless(equal(pub0010RepairDRC axlDBControl('drcEnable)) && equal(pub0010RepairFill axlDBControl('dynamicFillMode)) error("PUB0010 bounded attachments changed DRC/fill mode\n"))
  unless(axlSaveDesign(?design strcat(dir "/PUB0010_PARTIAL_UNAPPROVED.brd") ?noMru t ?noConfirm t) error("PUB0010 bounded attachment candidate save failed\n"))
  pub403FullTypedGate(strcat(pub403Bundle "/TARGET_FULL2698_WITH_NONLOGICAL_IDENTITIES.ilist")) pub403StateGate(strcat(pub403Bundle "/SOURCE_CONTROL_EXPECTED_ALL593_TEXT_PROPS.ilist"))
  f=outfile(strcat(dir "/UNAPPROVED_PARTIAL_SAVED_COMPLETE.txt")) fprintf(f "PUB0010_UNAPPROVED_PARTIAL_ONLY\nPAD_INTERNAL_STUBS=%d\nSOURCE_BRANCH_GROUPS=877\nUNRESOLVED_BRANCHES=%d\nUNRESOLVED54_EXACT_ENTITY_POSTCHECK=%d\nSOURCE_VIAS_STILL_PENDING_ORIGINAL_NET=%d\nSOURCE2068_STROKES_NOT_COVERED_CURRENT_OWN_NET=%d\nALL2698_593_TEXT_PROPS_EXACT\nALL1739_VIA_XY_PAD_PROPS_EXACT_AND_NET_ONLY_FROZEN_SOURCE_OR_FROZEN_INPUT_NIL\nFULL915_ACTUAL_CONNECTION_PARTITION_SOURCE_CU_AND_CFX_FINAL_GATES_NOT_APPROVED\n" count failed length(pub0010Unresolved54) pub0010ViaPendingCount length(pub0010MissingCuRows)) close(f) count))

; Partial stage is NOT permission for an unbounded via/net change. Every via
; has exactly its original XY/pad/properties. Only the nine already-frozen input
; NIL nets may remain NIL; no third net, missing/extra via or multiplicity loss.
procedure(pub0010PartialViaGate(dir)
 let((source current before consumed f pending sourceKey candidates)
  unless(length(pub0010OriginalViaNativeRows)==1739 && length(pub0010InputViaNativeRows)==1739 && length(pub0010ViaRows)==1739 error("PUB0010 bounded partial via coverage incomplete\n"))
  consumed=nil pending=0 f=outfile(strcat(dir "/ALL1739_VIA_SOURCE_OR_FROZEN_INPUT_STATE_REVIEW.ilist"))
  foreach(source pub0010OriginalViaNativeRows
   candidates=setof(v pub0010ViaRows equal(car(v) car(source)) && equal(nth(1 v) nth(1 source)))
   unless(length(candidates)==1 error("PUB0010 partial via exactXY/pad identity missing/duplicate\n")) current=car(candidates)
   before=car(setof(v pub0010InputViaNativeRows equal(car(v) car(source)) && equal(nth(1 v) nth(1 source))))
   unless(before && equal(nth(3 source) nth(3 current)) && equal(nth(3 before) nth(3 current)) error("PUB0010 partial via original full properties changed\n"))
   unless(equal(nth(2 before) nth(2 source)) || equal(nth(2 before) "__NO_NET__") error("PUB0010 partial input via differs beyond source-or-NIL\n"))
   unless(equal(nth(2 current) nth(2 source)) || equal(nth(2 before) "__NO_NET__") && equal(nth(2 current) "__NO_NET__") error("PUB0010 partial via acquired unapproved third net\n"))
   unless(equal(nth(2 current) nth(2 source)) pending=pending+1)
   consumed=cons(current consumed) fprintf(f "%L\n" list(source before current))) close(f)
  unless(length(consumed)==1739 error("PUB0010 partial typed via multiplicity differs\n"))
  pub0010ViaPendingCount=pending t))

procedure(pub0010FrozenInputViaGate(actual)
 let((rows expected)
  rows=pub403Rows("D:/001DIY/005lib/01AIEDA/library_maintenance/20261025_pc_shared/public0010_route_net_diagnostic_run13_v1/ACTUAL_ALL1739_VIAS.ilist")
  expected=nil
  foreach(r rows expected=cons(sprintf(nil "%L" list(car(r) nth(1 r) nth(2 r) sort(nth(3 r) lambda((a b) alphalessp(sprintf(nil "%L" a) sprintf(nil "%L" b)))))) expected))
  expected=sort(expected 'alphalessp)
  unless(length(rows)==1739 && equal(actual expected) error("PUB0010 partial input is not frozen exact1739via set with only9 known NIL nets\n")) t))
