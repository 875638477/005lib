; Root-owned independent final readonly reload evidence. No setter/create/save.
load("D:/001DIY/005lib/01AIEDA/library_maintenance/20261025_pc_shared/tools/public_brd_noop_full_readonly_v3.il")
load("D:/001DIY/005lib/01AIEDA/library_maintenance/20261025_pc_shared/tools/public0010_body_max_readonly27.il")
load("D:/001DIY/005lib/01AIEDA/library_maintenance/20261025_pc_shared/tools/public0010_final593_readonly_v1.il")
load("D:/001DIY/004computer/lga1700/cadence_geometry_merge_20261025/dra_audit/export.il")
procedure(pub27FinalAllDefinitionGraph(dir)
 let((f seen n)
  f=outfile(strcat(dir "/FINAL_ALL_CACHED_DEFINITION_GRAPHS.ilist"))
  seen=makeTable('pub27FullCacheGraphSeen nil) n=0
  foreach(z axlDBGetDesign()->symdefs draAuditVisit(z f seen) n=n+1) close(f)
  f=outfile(strcat(dir "/FINAL_ALL_CACHED_DEFINITIONS_COMPLETE.txt"))
  fprintf(f "COMPLETE_ALL_SYMDEFS_INCLUDING_UNUSED\nDEFINITIONS=%d\nNO_CREATE_NO_SAVE\n" n) close(f) n))
procedure(pub27Final0010FullComposite(dir)
 let((f)
  pub13FullReadOnly(dir)
  pub27BodyMaxReadonly(dir t)
  pub0010Final593Readonly(dir)
  pub27FinalAllDefinitionGraph(dir)
  f=outfile(strcat(dir "/FINAL_FULL_BODY_MAX_593_COMPOSITE_COMPLETE.txt"))
  fprintf(f "INDEPENDENT_READONLY_RELOAD_FULL_CU_2698_PARTITIONS_CFX_101_DEVICE_BODIES_MAX_DICT_ALL593_TEXT_PROPERTIES\nNO_CAD_SAVE_OR_PHYSICAL_MUTATION\n") close(f) t))
