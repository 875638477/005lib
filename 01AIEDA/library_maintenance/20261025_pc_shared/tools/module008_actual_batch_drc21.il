; Exact actual-source CLASS repair only on owned independent8482candidate copy.
procedure(pub14CheckClassRows(rows restored)
 let((d byref c row expected)
  d=axlDBGetDesign() axlDBRefreshId(d) unless(length(d->components)==1643 error("Full1643 component count changed\n"))
  byref=makeTable('pub14ClassesByRef nil)
  foreach(c d->components axlDBRefreshId(c) axlDBRefreshId(c->compdef) when(byref[c->name] error("Duplicate actual component ref\n")) byref[c->name]=c)
  foreach(row rows
   c=byref[car(row)] unless(c error("Exact original ref missing\n"))
   expected=if(restored then nth(4 row) else nth(3 row))
   unless(equal(c->deviceType nth(1 row)) && equal(c->compdef->deviceType nth(1 row)) && equal(c->package nth(2 row)) && equal(c->class expected) && equal(c->compdef->class expected) printf("BAD_REF=%L EXPECTED_ROW=%L ACTUAL_DT=%L ACTUAL_COMPDEF_DT=%L ACTUAL_PACKAGE=%L ACTUAL_COMPONENT_CLASS=%L ACTUAL_COMPDEF_CLASS=%L RESTORED_MODE=%L\n" car(row) row c->deviceType c->compdef->deviceType c->package c->class c->compdef->class restored) error("Exact ref/device/package/CLASS precondition failed\n"))) t))

load("D:/001DIY/004computer/lga1700/12electrical_fixed_20261025/rules/replay/native_constraints_helpers.il")
procedure(pub21ExportCNS(dir stem)
 let((d a b x)
  axlCMDBInit() d=cmxlFindObject(REDS_DESIGN_OBJ) unless(d error("CMXL design missing\n")) cmxlDBSkillInit(d)
  a=cmxlExportFile(d strcat(dir "/" stem ".dcfx")) b=cmxlExportFile(d strcat(dir "/" stem ".tcfx")) x=axlCMDBExit()
  unless(a==1 && b==1 && x==0 error("Complete native CNS evidence export failed\n")) t))
procedure(pub21DumpDRC(dir stem)
 let((d f x)
  d=axlDBGetDesign() axlDBRefreshId(d) f=outfile(strcat(dir "/" stem ".ilist"))
  fprintf(f "DRC_STATE=%L\nDRC_COUNT=%L\n" d->drcState axlDRCGetCount())
  foreach(x d->drcs fprintf(f "DRC_DBID=%L FULL_NATIVE_ATTRIBUTES=%L USER_AND_ALLEGRO_PROPERTIES=%L\n" x x->?? axlDBGetProperties(x '("user" "allegro")))) close(f) t))
procedure(pub21Module008BatchDRC(dir)
 let((rows d f r count s)
  rows=list(list("R220" "R_R0201_200R/0201/1%_" "R0201_PC" "IC" "IC") list("R217" "R_R0201_200R/0201/1%_" "R0201_PC" "IC" "IC") list("R219" "R_R0201_200R/0201/1%_" "R0201_PC" "IC" "IC") list("R223" "R_R0402_47K/0402/1%_" "R0402_PC" "IC" "IC") list("R224" "R_R0402_47K/0402/1%_" "R0402_PC" "IC" "IC") list("R222" "R_R0402_47K/0402/1%_" "R0402_PC" "IC" "IC") list("R21" "R_R0402_47K/0402/1%_" "R0402_PC" "IC" "IC") list("R25" "R_R0402_47K/0402/1%_" "R0402_PC" "IC" "IC") list("R11" "R_R0402_47K/0402/1%_" "R0402_PC" "IC" "IC") list("R19" "R_R0402_47K/0402/1%_" "R0402_PC" "IC" "IC") list("R17" "R_R0402_47K/0402/1%_" "R0402_PC" "IC" "IC") list("R15" "R_R0402_47K/0402/1%_" "R0402_PC" "IC" "IC") list("R13" "R_R0402_47K/0402/1%_" "R0402_PC" "IC" "IC") list("R106" "R_R0402_0R/0402/1%_" "R0402_PC" "DISCRETE" "DISCRETE") list("R100" "R_R0402_0R/0402/1%_" "R0402_PC" "DISCRETE" "DISCRETE") list("R225" "R_R0402_0R/0402/1%_" "R0402_PC" "DISCRETE" "DISCRETE") list("R122" "R_R0402_0R/0402/1%_" "R0402_PC" "DISCRETE" "DISCRETE") list("RT91" "R_R0402_0R/0402/1%_" "R0402_PC" "DISCRETE" "DISCRETE") list("RT65" "R_R0402_0R/0402/1%_" "R0402_PC" "DISCRETE" "DISCRETE") list("RT66" "R_R0402_0R/0402/1%_" "R0402_PC" "DISCRETE" "DISCRETE") list("RT76" "R_R0402_0R/0402/1%_" "R0402_PC" "DISCRETE" "DISCRETE") list("RT75" "R_R0402_0R/0402/1%_" "R0402_PC" "DISCRETE" "DISCRETE") list("RT20" "R_R0402_0R/0402/1%_" "R0402_PC" "DISCRETE" "DISCRETE") list("RT30" "R_R0402_0R/0402/1%_" "R0402_PC" "DISCRETE" "DISCRETE") list("RT27" "R_R0402_0R/0402/1%_" "R0402_PC" "DISCRETE" "DISCRETE") list("RT26" "R_R0402_0R/0402/1%_" "R0402_PC" "DISCRETE" "DISCRETE") list("RB45" "R_R0402_0R/0402/1%_" "R0402_PC" "DISCRETE" "DISCRETE") list("RB46" "R_R0402_0R/0402/1%_" "R0402_PC" "DISCRETE" "DISCRETE") list("R175" "R_R0402_0R/0402/1%_" "R0402_PC" "DISCRETE" "DISCRETE") list("R274" "R_R0402_0R/0402/1%_" "R0402_PC" "DISCRETE" "DISCRETE") list("R95" "R_R0402_0R/0402/1%_" "R0402_PC" "DISCRETE" "DISCRETE") list("R10" "R_R0402_0R/0402/1%_" "R0402_PC" "DISCRETE" "DISCRETE") list("RB54" "R_R0402_0R/0402/1%_" "R0402_PC" "DISCRETE" "DISCRETE") list("RB53" "R_R0402_0R/0402/1%_" "R0402_PC" "DISCRETE" "DISCRETE") list("RB34" "R_R0402_0R/0402/1%_" "R0402_PC" "DISCRETE" "DISCRETE") list("RB39" "R_R0402_0R/0402/1%_" "R0402_PC" "DISCRETE" "DISCRETE") list("RB36" "R_R0402_0R/0402/1%_" "R0402_PC" "DISCRETE" "DISCRETE") list("RB37" "R_R0402_0R/0402/1%_" "R0402_PC" "DISCRETE" "DISCRETE") list("R20" "R_R0402_0R/0402/1%_" "R0402_PC" "DISCRETE" "DISCRETE") list("R273" "R_R0402_0R/0402/1%_" "R0402_PC" "DISCRETE" "DISCRETE") list("R182" "R_R0402_0R/0402/1%_" "R0402_PC" "DISCRETE" "DISCRETE") list("RB35" "R_R0402_0R/0402/1%_" "R0402_PC" "DISCRETE" "DISCRETE") list("RB48" "R_R0402_0R/0402/1%_" "R0402_PC" "DISCRETE" "DISCRETE") list("RB47" "R_R0402_0R/0402/1%_" "R0402_PC" "DISCRETE" "DISCRETE") list("RB49" "R_R0402_0R/0402/1%_" "R0402_PC" "DISCRETE" "DISCRETE") list("RB38" "R_R0402_0R/0402/1%_" "R0402_PC" "DISCRETE" "DISCRETE") list("R250" "R_R0402_0R/0402/1%_" "R0402_PC" "DISCRETE" "DISCRETE") list("RB41" "R_R0402_0R/0402/1%_" "R0402_PC" "DISCRETE" "DISCRETE") list("R261" "R_R0402_0R/0402/1%_" "R0402_PC" "DISCRETE" "DISCRETE") list("RB43" "R_R0402_0R/0402/1%_" "R0402_PC" "DISCRETE" "DISCRETE") list("RB51" "R_R0402_0R/0402/1%_" "R0402_PC" "DISCRETE" "DISCRETE") list("RB4" "R_R0402_0R/0402/1%_" "R0402_PC" "DISCRETE" "DISCRETE") list("RB5" "R_R0402_0R/0402/1%_" "R0402_PC" "DISCRETE" "DISCRETE") list("R51" "R_R0402_0R/0402/1%_" "R0402_PC" "DISCRETE" "DISCRETE") list("R48" "R_R0402_0R/0402/1%_" "R0402_PC" "DISCRETE" "DISCRETE") list("RB7" "R_R0402_0R/0402/1%_" "R0402_PC" "DISCRETE" "DISCRETE") list("RB8" "R_R0402_0R/0402/1%_" "R0402_PC" "DISCRETE" "DISCRETE") list("R71" "R_R0402_0R/0402/1%_" "R0402_PC" "DISCRETE" "DISCRETE") list("R287" "R_R0402_0R/0402/1%_" "R0402_PC" "DISCRETE" "DISCRETE") list("R121" "R_R0402_0R/0402/1%_" "R0402_PC" "DISCRETE" "DISCRETE") list("RB62" "R_R0402_0R/0402/1%_" "R0402_PC" "DISCRETE" "DISCRETE") list("RB61" "R_R0402_0R/0402/1%_" "R0402_PC" "DISCRETE" "DISCRETE") list("R87" "R_R0402_10K/0402/1%_" "R0402_PC" "DISCRETE" "DISCRETE") list("R218" "R_R0402_10K/0402/1%_" "R0402_PC" "DISCRETE" "DISCRETE") list("R215" "R_R0402_10K/0402/1%_" "R0402_PC" "DISCRETE" "DISCRETE") list("R176" "R_R0402_10K/0402/1%_" "R0402_PC" "DISCRETE" "DISCRETE") list("R178" "R_R0402_10K/0402/1%_" "R0402_PC" "DISCRETE" "DISCRETE") list("R281" "R_R0402_10K/0402/1%_" "R0402_PC" "DISCRETE" "DISCRETE") list("R282" "R_R0402_10K/0402/1%_" "R0402_PC" "DISCRETE" "DISCRETE") list("RT21" "R_R0402_10K/0402/1%_" "R0402_PC" "DISCRETE" "DISCRETE") list("RT9" "R_R0402_10K/0402/1%_" "R0402_PC" "DISCRETE" "DISCRETE") list("RT17" "R_R0402_10K/0402/1%_" "R0402_PC" "DISCRETE" "DISCRETE") list("RT18" "R_R0402_10K/0402/1%_" "R0402_PC" "DISCRETE" "DISCRETE") list("RT24" "R_R0402_10K/0402/1%_" "R0402_PC" "DISCRETE" "DISCRETE") list("RT80" "R_R0402_10K/0402/1%_" "R0402_PC" "DISCRETE" "DISCRETE") list("RT94" "R_R0402_10K/0402/1%_" "R0402_PC" "DISCRETE" "DISCRETE") list("RT92" "R_R0402_10K/0402/1%_" "R0402_PC" "DISCRETE" "DISCRETE") list("RT89" "R_R0402_10K/0402/1%_" "R0402_PC" "DISCRETE" "DISCRETE") list("RB24" "R_R0402_10K/0402/1%_" "R0402_PC" "DISCRETE" "DISCRETE") list("RT71" "R_R0402_10K/0402/1%_" "R0402_PC" "DISCRETE" "DISCRETE") list("RT2" "R_R0402_10K/0402/1%_" "R0402_PC" "DISCRETE" "DISCRETE") list("R195" "R_R0402_10K/0402/1%_" "R0402_PC" "DISCRETE" "DISCRETE") list("R127" "R_R0402_10K/0402/1%_" "R0402_PC" "DISCRETE" "DISCRETE") list("R105" "R_R0402_10K/0402/1%_" "R0402_PC" "DISCRETE" "DISCRETE") list("R117" "R_R0402_10K/0402/1%_" "R0402_PC" "DISCRETE" "DISCRETE") list("R116" "R_R0402_10K/0402/1%_" "R0402_PC" "DISCRETE" "DISCRETE") list("RT33" "R_R0402_10K/0402/1%_" "R0402_PC" "DISCRETE" "DISCRETE") list("R209" "R_R0402_10K/0402/1%_" "R0402_PC" "DISCRETE" "DISCRETE") list("R211" "R_R0402_10K/0402/1%_" "R0402_PC" "DISCRETE" "DISCRETE") list("R204" "R_R0402_10K/0402/1%_" "R0402_PC" "DISCRETE" "DISCRETE") list("R205" "R_R0402_10K/0402/1%_" "R0402_PC" "DISCRETE" "DISCRETE") list("R6" "R_R0402_10K/0402/1%_" "R0402_PC" "DISCRETE" "DISCRETE") list("R120" "R_R0402_10K/0402/1%_" "R0402_PC" "DISCRETE" "DISCRETE") list("RT14" "R_R0402_10K/0402/1%_" "R0402_PC" "DISCRETE" "DISCRETE") list("FB9" "FR_L0603_CVB1608E600T_" "FB0603_PC" "IC" "IC") list("FB1" "FR_L0603_CVB1608E600T_" "FB0603_PC" "IC" "IC") list("FB3" "FR_L0603_CVB1608E600T_" "FB0603_PC" "IC" "IC") list("FB6" "FR_L0603_CVB1608E600T_" "FB0603_PC" "IC" "IC") list("FB7" "FR_L0603_CVB1608E600T_" "FB0603_PC" "IC" "IC") list("FBT9" "FR_L0603_CVB1608E600T_" "FB0603_PC" "IC" "IC") list("FBT3" "FR_L0603_CVB1608E600T_" "FB0603_PC" "IC" "IC") list("FBT7" "FR_L0603_CVB1608E600T_" "FB0603_PC" "IC" "IC") list("FBT6" "FR_L0603_CVB1608E600T_" "FB0603_PC" "IC" "IC") list("FBT12" "FR_L0603_CVB1608E600T_" "FB0603_PC" "IC" "IC") list("FBT10" "FR_L0603_CVB1608E600T_" "FB0603_PC" "IC" "IC") list("FBT14" "FR_L0603_CVB1608E600T_" "FB0603_PC" "IC" "IC") list("FBT4" "FR_L0603_CVB1608E600T_" "FB0603_PC" "IC" "IC") list("C146" "CAP_C0402_1UF/0402/6.3V/10%_" "C0402_PC" "IC" "DISCRETE") list("C159" "CAP_C0402_1UF/0402/6.3V/10%_" "C0402_PC" "IC" "DISCRETE") list("C147" "CAP_C0402_1UF/0402/6.3V/10%_" "C0402_PC" "IC" "DISCRETE") list("C360" "CAP_C0402_1UF/0402/6.3V/10%_" "C0402_PC" "IC" "DISCRETE") list("C151" "CAP_C0402_1UF/0402/6.3V/10%_" "C0402_PC" "IC" "DISCRETE") list("C128" "CAP_C0402_1UF/0402/6.3V/10%_" "C0402_PC" "IC" "DISCRETE") list("C115" "CAP_C0402_1UF/0402/6.3V/10%_" "C0402_PC" "IC" "DISCRETE") list("C123" "CAP_C0402_1UF/0402/6.3V/10%_" "C0402_PC" "IC" "DISCRETE") list("C116" "CAP_C0402_1UF/0402/6.3V/10%_" "C0402_PC" "IC" "DISCRETE") list("C164" "CAP_C0402_1UF/0402/6.3V/10%_" "C0402_PC" "IC" "DISCRETE") list("C172" "CAP_C0402_1UF/0402/6.3V/10%_" "C0402_PC" "IC" "DISCRETE") list("C156" "CAP_C0402_1UF/0402/6.3V/10%_" "C0402_PC" "IC" "DISCRETE") list("C170" "CAP_C0402_1UF/0402/6.3V/10%_" "C0402_PC" "IC" "DISCRETE") list("C137" "CAP_C0402_1UF/0402/6.3V/10%_" "C0402_PC" "IC" "DISCRETE") list("C383" "CAP_C0402_1UF/0402/6.3V/10%_" "C0402_PC" "IC" "DISCRETE") list("C382" "CAP_C0402_1UF/0402/6.3V/10%_" "C0402_PC" "IC" "DISCRETE") list("C381" "CAP_C0402_1UF/0402/6.3V/10%_" "C0402_PC" "IC" "DISCRETE") list("C380" "CAP_C0402_1UF/0402/6.3V/10%_" "C0402_PC" "IC" "DISCRETE") list("C148" "CAP_C0402_1UF/0402/6.3V/10%_" "C0402_PC" "IC" "DISCRETE") list("C141" "CAP_C0402_1UF/0402/6.3V/10%_" "C0402_PC" "IC" "DISCRETE") list("C181" "CAP_C0402_NC_1.8PF_" "C0402_PC" "IC" "IC") list("C177" "CAP_C0402_NC_1.8PF_" "C0402_PC" "IC" "IC") list("C376" "CAP_C0402_NC_1.8PF_" "C0402_PC" "IC" "IC") list("C25" "CAP_C0402_NC_000200000035" "C0402_PC" "IC" "IC") list("C92" "CAP_C0402_NC_000200000035" "C0402_PC" "IC" "IC") list("C57" "CAP_C0402_NC_000200000035" "C0402_PC" "IC" "IC") list("C58" "CAP_C0402_NC_000200000035" "C0402_PC" "IC" "IC") list("C16" "CAP_C0402_NC_000200000035" "C0402_PC" "IC" "IC") list("C114" "CAP_C0402_NC_000200000035" "C0402_PC" "IC" "IC") list("R66" "R_R0402_NC_R0402_000000000041" "R0402_PC" "IC" "IC") list("R172" "R_R0402_NC_R0402_000000000041" "R0402_PC" "IC" "IC") list("R76" "R_R0402_NC_R0402_000000000041" "R0402_PC" "IC" "IC") list("R203" "R_R0402_2M/0402/1%_000000000041" "R0402_PC" "IC" "IC") list("C278" "CAP2_C0402_2.2UF/0402/6.3V/10%" "C0402_PC" "IC" "IC") list("C167" "CAP_C0402_4.7UF/0402/10V/10%_" "C0402_PC" "DISCRETE" "DISCRETE") list("C201" "CAP_C0402_4.7UF/0402/10V/10%_" "C0402_PC" "DISCRETE" "DISCRETE") list("C219" "CAP_C0402_4.7UF/0402/10V/10%_" "C0402_PC" "DISCRETE" "DISCRETE") list("C203" "CAP_C0402_4.7UF/0402/10V/10%_" "C0402_PC" "DISCRETE" "DISCRETE") list("C190" "CAP_C0402_4.7UF/0402/10V/10%_" "C0402_PC" "DISCRETE" "DISCRETE") list("C357" "CAP_C0402_4.7UF/0402/10V/10%_" "C0402_PC" "DISCRETE" "DISCRETE") list("C353" "CAP_C0402_4.7UF/0402/10V/10%_" "C0402_PC" "DISCRETE" "DISCRETE") list("C166" "CAP_C0402_4.7UF/0402/10V/10%_" "C0402_PC" "DISCRETE" "DISCRETE") list("CT5" "CAP_C0402_4.7UF/0402/10V/10%_" "C0402_PC" "DISCRETE" "DISCRETE") list("CT20" "CAP_C0402_4.7UF/0402/10V/10%_" "C0402_PC" "DISCRETE" "DISCRETE") list("CT129" "CAP_C0402_4.7UF/0402/10V/10%_" "C0402_PC" "DISCRETE" "DISCRETE") list("CT131" "CAP_C0402_4.7UF/0402/10V/10%_" "C0402_PC" "DISCRETE" "DISCRETE") list("CT124" "CAP_C0402_4.7UF/0402/10V/10%_" "C0402_PC" "DISCRETE" "DISCRETE") list("CT1" "CAP_C0402_4.7UF/0402/10V/10%_" "C0402_PC" "DISCRETE" "DISCRETE") list("CB21" "CAP_C0402_4.7UF/0402/10V/10%_" "C0402_PC" "DISCRETE" "DISCRETE") list("CB20" "CAP_C0402_4.7UF/0402/10V/10%_" "C0402_PC" "DISCRETE" "DISCRETE") list("C39" "CAP_C0402_4.7UF/0402/10V/10%_" "C0402_PC" "DISCRETE" "DISCRETE") list("C38" "CAP_C0402_4.7UF/0402/10V/10%_" "C0402_PC" "DISCRETE" "DISCRETE") list("C370" "CAP_C0402_4.7UF/0402/10V/10%_" "C0402_PC" "DISCRETE" "DISCRETE") list("C372" "CAP_C0402_4.7UF/0402/10V/10%_" "C0402_PC" "DISCRETE" "DISCRETE") list("C77" "CAP_C0402_NC_22PF/0402/50V/10%_" "C0402_PC" "IC" "IC") list("C52" "CAP_C0402_NC_22PF/0402/50V/10%_" "C0402_PC" "IC" "IC") list("C42" "CAP_C0402_NC_22PF/0402/50V/10%_" "C0402_PC" "IC" "IC") list("C111" "CAP_C0402_NC_22PF/0402/50V/10%_" "C0402_PC" "IC" "IC") list("C26" "CAP_C0402_NC_22PF/0402/50V/10%_" "C0402_PC" "IC" "IC") list("C64" "CAP_C0402_NC_22PF/0402/50V/10%_" "C0402_PC" "IC" "IC") list("C304" "CAP2_C0201_10NF/0201/6.3V/10%" "C0201_PC" "IC" "IC") list("C242" "CAP2_C0201_10NF/0201/6.3V/10%" "C0201_PC" "IC" "IC") list("C235" "CAP2_C0201_10NF/0201/6.3V/10%" "C0201_PC" "IC" "IC") list("C297" "CAP2_C0201_10NF/0201/6.3V/10%" "C0201_PC" "IC" "IC") list("C308" "CAP2_C0201_10NF/0201/6.3V/10%" "C0201_PC" "IC" "IC") list("C300" "CAP2_C0201_10NF/0201/6.3V/10%" "C0201_PC" "IC" "IC") list("C272" "CAP2_C0201_10NF/0201/6.3V/10%" "C0201_PC" "IC" "IC") list("C311" "CAP2_C0201_NC_C0201" "C0201_PC" "IC" "IC") list("C250" "CAP2_C0201_NC_C0201" "C0201_PC" "IC" "IC") list("C257" "CAP2_C0201_NC_C0201" "C0201_PC" "IC" "IC") list("C312" "CAP2_C0201_NC_C0201" "C0201_PC" "IC" "IC") list("C292" "CAP2_C0201_100NF/0201/10V/10%" "C0201_PC" "IC" "IC") list("C259" "CAP2_C0201_100NF/0201/10V/10%" "C0201_PC" "IC" "IC") list("C264" "CAP2_C0201_100NF/0201/10V/10%" "C0201_PC" "IC" "IC") list("C286" "CAP2_C0201_100NF/0201/10V/10%" "C0201_PC" "IC" "IC") list("C302" "CAP2_C0201_100NF/0201/10V/10%" "C0201_PC" "IC" "IC") list("C226" "CAP2_C0201_100NF/0201/10V/10%" "C0201_PC" "IC" "IC") list("C268" "CAP2_C0201_100NF/0201/10V/10%" "C0201_PC" "IC" "IC") list("C234" "CAP2_C0201_100NF/0201/10V/10%" "C0201_PC" "IC" "IC") list("C289" "CAP2_C0201_100NF/0201/10V/10%" "C0201_PC" "IC" "IC") list("C319" "CAP2_C0201_100NF/0201/10V/10%" "C0201_PC" "IC" "IC") list("C309" "CAP2_C0201_100NF/0201/10V/10%" "C0201_PC" "IC" "IC") list("C328" "CAP2_C0201_100NF/0201/10V/10%" "C0201_PC" "IC" "IC") list("C253" "CAP2_C0201_100NF/0201/10V/10%" "C0201_PC" "IC" "IC") list("C236" "CAP2_C0201_100NF/0201/10V/10%" "C0201_PC" "IC" "IC") list("C252" "CAP2_C0201_100NF/0201/10V/10%" "C0201_PC" "IC" "IC") list("C331" "CAP2_C0201_100NF/0201/10V/10%" "C0201_PC" "IC" "IC") list("C269" "CAP2_C0201_100NF/0201/10V/10%" "C0201_PC" "IC" "IC") list("C327" "CAP2_C0201_100NF/0201/10V/10%" "C0201_PC" "IC" "IC") list("C296" "CAP2_C0201_100NF/0201/10V/10%" "C0201_PC" "IC" "IC") list("C307" "CAP2_C0201_100NF/0201/10V/10%" "C0201_PC" "IC" "IC") list("C295" "CAP2_C0201_100NF/0201/10V/10%" "C0201_PC" "IC" "IC") list("C228" "CAP2_C0201_100NF/0201/10V/10%" "C0201_PC" "IC" "IC") list("C298" "CAP2_C0201_100NF/0201/10V/10%" "C0201_PC" "IC" "IC") list("C270" "CAP2_C0201_100NF/0201/10V/10%" "C0201_PC" "IC" "IC") list("C336" "CAP2_C0201_100NF/0201/10V/10%" "C0201_PC" "IC" "IC") list("C220" "CAP2_C0201_100NF/0201/10V/10%" "C0201_PC" "IC" "IC") list("C239" "CAP2_C0201_100NF/0201/10V/10%" "C0201_PC" "IC" "IC") list("C231" "CAP2_C0201_100NF/0201/10V/10%" "C0201_PC" "IC" "IC") list("C325" "CAP2_C0201_100NF/0201/10V/10%" "C0201_PC" "IC" "IC") list("C211" "CAP2_C0201_100NF/0201/10V/10%" "C0201_PC" "IC" "IC") list("C247" "CAP2_C0201_100NF/0201/10V/10%" "C0201_PC" "IC" "IC") list("C282" "CAP2_C0201_100NF/0201/10V/10%" "C0201_PC" "IC" "IC") list("C256" "CAP2_C0201_100NF/0201/10V/10%" "C0201_PC" "IC" "IC") list("C384" "CAP2_C0201_100NF/0201/10V/10%" "C0201_PC" "IC" "IC") list("C385" "CAP2_C0201_100NF/0201/10V/10%" "C0201_PC" "IC" "IC") list("C386" "CAP2_C0201_100NF/0201/10V/10%" "C0201_PC" "IC" "IC") list("C317" "CAP2_C0201_1UF/0201/6.3V/10%" "C0201_PC" "IC" "IC") list("C261" "CAP2_C0201_1UF/0201/6.3V/10%" "C0201_PC" "IC" "IC") list("C246" "CAP2_C0201_1UF/0201/6.3V/10%" "C0201_PC" "IC" "IC") list("C299" "CAP2_C0201_1UF/0201/6.3V/10%" "C0201_PC" "IC" "IC") list("C301" "CAP2_C0201_1UF/0201/6.3V/10%" "C0201_PC" "IC" "IC") list("C291" "CAP2_C0201_1UF/0201/6.3V/10%" "C0201_PC" "IC" "IC") list("C241" "CAP2_C0201_1UF/0201/6.3V/10%" "C0201_PC" "IC" "IC") list("C313" "CAP2_C0201_1UF/0201/6.3V/10%" "C0201_PC" "IC" "IC") list("C265" "CAP2_C0201_1UF/0201/6.3V/10%" "C0201_PC" "IC" "IC") list("C288" "CAP2_C0201_1UF/0201/6.3V/10%" "C0201_PC" "IC" "IC") list("C254" "CAP2_C0201_1UF/0201/6.3V/10%" "C0201_PC" "IC" "IC") list("C229" "CAP2_C0201_1UF/0201/6.3V/10%" "C0201_PC" "IC" "IC") list("C324" "CAP2_C0201_1UF/0201/6.3V/10%" "C0201_PC" "IC" "IC") list("C208" "CAP2_C0201_1UF/0201/6.3V/10%" "C0201_PC" "IC" "IC") list("C306" "CAP2_C0201_1UF/0201/6.3V/10%" "C0201_PC" "IC" "IC") list("C315" "CAP2_C0201_1UF/0201/6.3V/10%" "C0201_PC" "IC" "IC") list("C277" "CAP2_C0402_4.7UF/0402/10V/10%" "C0402_PC" "IC" "IC") list("C279" "CAP2_C0402_4.7UF/0402/10V/10%" "C0402_PC" "IC" "IC") list("C248" "CAP2_C0402_4.7UF/0402/10V/10%" "C0402_PC" "IC" "IC") list("C294" "CAP2_C0402_4.7UF/0402/10V/10%" "C0402_PC" "IC" "IC") list("C275" "CAP2_C0402_4.7UF/0402/10V/10%" "C0402_PC" "IC" "IC") list("C195" "CAP2_C0402_4.7UF/0402/10V/10%" "C0402_PC" "IC" "IC") list("C187" "CAP2_C0402_4.7UF/0402/10V/10%" "C0402_PC" "IC" "IC") list("C69" "CAP2_C0402_4.7UF/0402/10V/10%" "C0402_PC" "IC" "IC") list("C200" "CAP2_C0402_4.7UF/0402/10V/10%" "C0402_PC" "IC" "IC") list("C204" "CAP2_C0402_4.7UF/0402/10V/10%" "C0402_PC" "IC" "IC") list("C209" "CAP2_C0402_4.7UF/0402/10V/10%" "C0402_PC" "IC" "IC") list("R133" "R_R0402_2.7K/0402/1%_" "R0402_PC" "IC" "IC") list("CMC7" "CMC_CMC1610-4P_CMF1210DH900MFR_" "CMC1610-4P" "DISCRETE" "DISCRETE") list("CMC1" "CMC_CMC1610-4P_CMF1210DH900MFR_" "CMC1610-4P" "DISCRETE" "DISCRETE") list("CMC2" "CMC_CMC1610-4P_CMF1210DH900MFR_" "CMC1610-4P" "DISCRETE" "DISCRETE") list("CMC3" "CMC_CMC1610-4P_CMF1210DH900MFR_" "CMC1610-4P" "DISCRETE" "DISCRETE") list("CMC4" "CMC_CMC1610-4P_CMF1210DH900MFR_" "CMC1610-4P" "DISCRETE" "DISCRETE") list("CMC5" "CMC_CMC1610-4P_CMF1210DH900MFR_" "CMC1610-4P" "DISCRETE" "DISCRETE") list("CMC6" "CMC_CMC1610-4P_CMF1210DH900MFR_" "CMC1610-4P" "DISCRETE" "DISCRETE") list("CMCT2" "CMC_CMC1610-4P_CMF1210DH900MFR_" "CMC1610-4P" "DISCRETE" "DISCRETE") list("CMC9" "CMC_CMC1610-4P_CMF1210DH900MFR_" "CMC1610-4P" "DISCRETE" "DISCRETE") list("CMC8" "CMC_CMC1610-4P_CMF1210DH900MFR_" "CMC1610-4P" "DISCRETE" "DISCRETE") list("D5" "SS24_SOD-323F_1N4148WS/SOD-323_" "SOD-323" "IC" "IC") list("D6" "SS24_SOD-323F_1N4148WS/SOD-323_" "SOD-323" "IC" "IC") list("DB2" "SS24_SOD-323F_1N4148WS/SOD-323_" "SOD-323" "IC" "IC") list("DB3" "SS24_SOD-323F_1N4148WS/SOD-323_" "SOD-323" "IC" "IC") list("DB4" "SS24_SOD-323F_1N4148WS/SOD-323_" "SOD-323" "IC" "IC") list("P1" "MM4829_BWIPX-1_IO_BWIPX-1-001E" "BWIPX-1" "IO" "IO") list("P2" "MM4829_BWIPX-1_IO_BWIPX-1-001E" "BWIPX-1" "IO" "IO") list("PT2" "MM4829_BWIPX-1_IO_BWIPX-1-001E" "BWIPX-1" "IO" "IO") list("PT1" "MM4829_BWIPX-1_IO_BWIPX-1-001E" "BWIPX-1" "IO" "IO") list("LB2" "FR_L0402_CVB1005E121T_" "FB0402_PC" "IC" "IC") list("LB7" "FR_L0402_CVB1005E121T_" "FB0402_PC" "IC" "IC") list("LB6" "FR_L0402_CVB1005E121T_" "FB0402_PC" "IC" "IC") list("LB3" "FR_L0402_CVB1005E121T_" "FB0402_PC" "IC" "IC") list("LB1" "FR_L0402_CVB1005E121T_" "FB0402_PC" "IC" "IC") list("LB4" "FR_L0402_CVB1005E121T_" "FB0402_PC" "IC" "IC") list("L1" "CD42-2R2UH_L0805_CVB2012E100T" "L0805_PC" "IC" "IC") list("FB5" "CD42-2R2UH_L0805_CVB2012E100T" "L0805_PC" "IC" "IC") list("L5" "CD42-2R2UH_L0805_CVB2012E100T" "L0805_PC" "IC" "IC") list("L2" "CD42-2R2UH_L0805_CVB2012E100T" "L0805_PC" "IC" "IC") list("L7" "CD42-2R2UH_L0805_CVB2012E100T" "L0805_PC" "IC" "IC") list("L6" "CD42-2R2UH_L0805_CVB2012E100T" "L0805_PC" "IC" "IC") list("L19" "CD42-2R2UH_L0805_CVB2012E100T" "L0805_PC" "IC" "IC") list("R103" "R_R0402_1K/0402/1%_" "R0402_PC" "DISCRETE" "DISCRETE") list("RT69" "R_R0402_1K/0402/1%_" "R0402_PC" "DISCRETE" "DISCRETE") list("RT1" "R_R0402_1K/0402/1%_" "R0402_PC" "DISCRETE" "DISCRETE") list("R230" "R_R0402_1K/0402/1%_" "R0402_PC" "DISCRETE" "DISCRETE") list("RB13" "R_R0402_1K/0402/1%_" "R0402_PC" "DISCRETE" "DISCRETE") list("RB12" "R_R0402_1K/0402/1%_" "R0402_PC" "DISCRETE" "DISCRETE") list("R4" "R_R0402_1K/0402/1%_" "R0402_PC" "DISCRETE" "DISCRETE") list("RT81" "R_R0402_1K/0402/1%_" "R0402_PC" "DISCRETE" "DISCRETE") list("R3" "R_R0402_100K/0402/1%_" "R0402_PC" "DISCRETE" "DISCRETE") list("RT87" "R_R0402_100K/0402/1%_" "R0402_PC" "DISCRETE" "DISCRETE") list("RB25" "R_R0402_100K/0402/1%_" "R0402_PC" "DISCRETE" "DISCRETE") list("RB2" "R_R0402_100K/0402/1%_" "R0402_PC" "DISCRETE" "DISCRETE") list("RB1" "R_R0402_100K/0402/1%_" "R0402_PC" "DISCRETE" "DISCRETE") list("RB31" "R_R0402_100K/0402/1%_" "R0402_PC" "DISCRETE" "DISCRETE") list("RB29" "R_R0402_100K/0402/1%_" "R0402_PC" "DISCRETE" "DISCRETE") list("R226" "R_R0402_100K/0402/1%_" "R0402_PC" "DISCRETE" "DISCRETE") list("RT98" "R_R0402_100K/0402/1%_" "R0402_PC" "DISCRETE" "DISCRETE") list("RT97" "R_R0402_100K/0402/1%_" "R0402_PC" "DISCRETE" "DISCRETE") list("R265" "R_R0402_4.7K/0402/1%_" "R0402_PC" "IC" "IC") list("R266" "R_R0402_4.7K/0402/1%_" "R0402_PC" "IC" "IC") list("R248" "R_R0402_4.7K/0402/1%_" "R0402_PC" "IC" "IC") list("R249" "R_R0402_4.7K/0402/1%_" "R0402_PC" "IC" "IC") list("RT12" "R_R0402_4.7K/0402/1%_" "R0402_PC" "IC" "IC") list("RB15" "R_R0402_4.7K/0402/1%_" "R0402_PC" "IC" "IC") list("RB14" "R_R0402_4.7K/0402/1%_" "R0402_PC" "IC" "IC") list("RB20" "R_R0402_4.7K/0402/1%_" "R0402_PC" "IC" "IC") list("R171" "R_R0402_4.7K/0402/1%_" "R0402_PC" "IC" "IC") list("R173" "R_R0402_4.7K/0402/1%_" "R0402_PC" "IC" "IC") list("R177" "R_R0402_4.7K/0402/1%_" "R0402_PC" "IC" "IC") list("R174" "R_R0402_4.7K/0402/1%_" "R0402_PC" "IC" "IC") list("R275" "R_R0402_4.7K/0402/1%_" "R0402_PC" "IC" "IC") list("R278" "R_R0402_4.7K/0402/1%_" "R0402_PC" "IC" "IC") list("R54" "R_R0402_4.7K/0402/1%_" "R0402_PC" "IC" "IC") list("R53" "R_R0402_4.7K/0402/1%_" "R0402_PC" "IC" "IC") list("R243" "R_R0402_4.7K/0402/1%_" "R0402_PC" "IC" "IC") list("R186" "R_R0402_4.7K/0402/1%_" "R0402_PC" "IC" "IC") list("R285" "R_R0402_4.7K/0402/1%_" "R0402_PC" "IC" "IC") list("R284" "R_R0402_4.7K/0402/1%_" "R0402_PC" "IC" "IC") list("R187" "R_R0402_4.7K/0402/1%_" "R0402_PC" "IC" "IC") list("R300" "R_R0402_4.7K/0402/1%_" "R0402_PC" "IC" "IC") list("R299" "R_R0402_4.7K/0402/1%_" "R0402_PC" "IC" "IC") list("Q18" "N-MOS2_SOT-523_2SK3019" "SOT-523" "IC" "IC") list("Q19" "N-MOS2_SOT-523_2SK3019" "SOT-523" "IC" "IC") list("Q12" "N-MOS2_SOT-523_2SK3019" "SOT-523" "IC" "IC") list("Q10" "N-MOS2_SOT-523_2SK3019" "SOT-523" "IC" "IC") list("Q20" "N-MOS2_SOT-523_2SK3019" "SOT-523" "IC" "IC") list("Q21" "N-MOS2_SOT-523_2SK3019" "SOT-523" "IC" "IC") list("Q1" "N-MOS2_SOT-523_2SK3019" "SOT-523" "IC" "IC") list("Q2" "N-MOS2_SOT-523_2SK3019" "SOT-523" "IC" "IC") list("Q14" "N-MOS2_SOT-523_2SK3019" "SOT-523" "IC" "IC") list("Q15" "N-MOS2_SOT-523_2SK3019" "SOT-523" "IC" "IC") list("R86" "R_R0402_120R/0402/1%_" "R0402_PC" "IC" "IC") list("R216" "R_R0402_150R/0402/1%_" "R0402_PC" "IC" "IC") list("R214" "R_R0402_150R/0402/1%_" "R0402_PC" "IC" "IC") list("R208" "R_R0402_240R/0402/1%_" "R0402_PC" "IC" "IC") list("R206" "R_R0402_240R/0402/1%_" "R0402_PC" "IC" "IC") list("D3" "PESD_R0402_ESD3EL3BF" "R0402_PC" "IC" "IC") list("DT43" "PESD_R0402_ESD3EL3BF" "R0402_PC" "IC" "IC") list("DT15" "PESD_R0402_ESD3EL3BF" "R0402_PC" "IC" "IC") list("D19" "PESD_R0402_ESD3EL3BF" "R0402_PC" "IC" "IC") list("D20" "PESD_R0402_ESD3EL3BF" "R0402_PC" "IC" "IC") list("D17" "PESD_R0402_ESD3EL3BF" "R0402_PC" "IC" "IC") list("D18" "PESD_R0402_ESD3EL3BF" "R0402_PC" "IC" "IC") list("D15" "PESD_R0402_ESD3EL3BF" "R0402_PC" "IC" "IC") list("D16" "PESD_R0402_ESD3EL3BF" "R0402_PC" "IC" "IC") list("D13" "PESD_R0402_ESD3EL3BF" "R0402_PC" "IC" "IC") list("D14" "PESD_R0402_ESD3EL3BF" "R0402_PC" "IC" "IC") list("D12" "PESD_R0402_ESD3EL3BF" "R0402_PC" "IC" "IC") list("D11" "PESD_R0402_ESD3EL3BF" "R0402_PC" "IC" "IC") list("D9" "PESD_R0402_ESD3EL3BF" "R0402_PC" "IC" "IC") list("DT64" "PESD_R0402_ESD3EL3BF" "R0402_PC" "IC" "IC") list("DT63" "PESD_R0402_ESD3EL3BF" "R0402_PC" "IC" "IC") list("C338" "CAP2_C0201_3.3NF/0201/10V/10%" "C0201_PC" "IC" "IC") list("C305" "CAP2_C0201_3.3NF/0201/10V/10%" "C0201_PC" "IC" "IC") list("C293" "CAP2_C0201_3.3NF/0201/10V/10%" "C0201_PC" "IC" "IC") list("C290" "CAP2_C0201_4.7NF/0201/6.3V/10%" "C0201_PC" "IC" "IC") list("C285" "CAP2_C0201_4.7NF/0201/6.3V/10%" "C0201_PC" "IC" "IC") list("C273" "CAP2_C0201_1.2NF/0201/6.3V/10%" "C0201_PC" "IC" "IC") list("C263" "CAP2_C0201_1.2NF/0201/6.3V/10%" "C0201_PC" "IC" "IC") list("C251" "CAP2_C0201_1.2NF/0201/6.3V/10%" "C0201_PC" "IC" "IC") list("C287" "CAP2_C0201_2.2NF/0201/6.3V/10%" "C0201_PC" "IC" "IC") list("C214" "CAP2_C0201_2.2NF/0201/6.3V/10%" "C0201_PC" "IC" "IC") list("C337" "CAP2_C0201_1.5NF/0201/6.3V/10%" "C0201_PC" "IC" "IC") list("C284" "CAP2_C0201_1.5NF/0201/6.3V/10%" "C0201_PC" "IC" "IC") list("C276" "CAP2_C0201_1.5NF/0201/6.3V/10%" "C0201_PC" "IC" "IC") list("C258" "CAP2_C0201_1.5NF/0201/6.3V/10%" "C0201_PC" "IC" "IC") list("C210" "CAP2_C0201_1.5NF/0201/6.3V/10%" "C0201_PC" "IC" "IC") list("R136" "R_R0402_1K/0402/1%_000000000041" "R0402_PC" "IC" "IC") list("R161" "R_R0402_1K/0402/1%_000000000041" "R0402_PC" "IC" "IC") list("R241" "R_R0402_1K/0402/1%_000000000041" "R0402_PC" "IC" "IC") list("R153" "R_R0402_1K/0402/1%_000000000041" "R0402_PC" "IC" "IC") list("R147" "R_R0402_1K/0402/1%_000000000041" "R0402_PC" "IC" "IC") list("R144" "R_R0402_1K/0402/1%_000000000041" "R0402_PC" "IC" "IC") list("R137" "R_R0402_1K/0402/1%_000000000041" "R0402_PC" "IC" "IC") list("R141" "R_R0402_1K/0402/1%_000000000041" "R0402_PC" "IC" "IC") list("R180" "R_R0402_1K/0402/1%_000000000041" "R0402_PC" "IC" "IC") list("R262" "R_R0402_1K/0402/1%_000000000041" "R0402_PC" "IC" "IC") list("C326" "CAP_C0201_100NF/0201/10V/10%_" "C0201_PC" "IC" "IC") list("C303" "CAP_C0201_1UF/0201/6.3V/10%_" "C0201_PC" "IC" "IC") list("C266" "CAP_C0201_1UF/0201/6.3V/10%_" "C0201_PC" "IC" "IC") list("C260" "CAP_C0201_1UF/0201/6.3V/10%_" "C0201_PC" "IC" "IC") list("C255" "CAP_C0201_1UF/0201/6.3V/10%_" "C0201_PC" "IC" "IC") list("C243" "CAP_C0201_1UF/0201/6.3V/10%_" "C0201_PC" "IC" "IC") list("C237" "CAP_C0201_1UF/0201/6.3V/10%_" "C0201_PC" "IC" "IC") list("C230" "CAP_C0201_1UF/0201/6.3V/10%_" "C0201_PC" "IC" "IC") list("C223" "CAP_C0201_1UF/0201/6.3V/10%_" "C0201_PC" "IC" "IC") list("C227" "CAP_C0201_1UF/0201/6.3V/10%_" "C0201_PC" "IC" "IC") list("C225" "CAP_C0201_1UF/0201/6.3V/10%_" "C0201_PC" "IC" "IC") list("C224" "CAP_C0201_1UF/0201/6.3V/10%_" "C0201_PC" "IC" "IC") list("C221" "CAP_C0201_1UF/0201/6.3V/10%_" "C0201_PC" "IC" "IC") list("C216" "CAP_C0201_1UF/0201/6.3V/10%_" "C0201_PC" "IC" "IC") list("C217" "CAP_C0201_1UF/0201/6.3V/10%_" "C0201_PC" "IC" "IC") list("C207" "CAP_C0201_1UF/0201/6.3V/10%_" "C0201_PC" "IC" "IC") list("L12" "L_L4318_AUPI0420-R22M_" "L4318_PC" "IC" "IC") list("L14" "L_L4318_AUPI0420-R47M_" "L4318_PC" "IC" "IC") list("L15" "L_L4318_AUPI0420-R47M_" "L4318_PC" "IC" "IC") list("L13" "L_L4318_AUPI0420-R47M_" "L4318_PC" "IC" "IC") list("L9" "L_L4318_AUPI0420-R47M_" "L4318_PC" "IC" "IC") list("L8" "L_L4318_AUPI0420-R47M_" "L4318_PC" "IC" "IC") list("L11" "L_L4318_AUPI0420-R47M_" "L4318_PC" "IC" "IC") list("L10" "L_L4318_AUPI0420-R47M_" "L4318_PC" "IC" "IC") list("Q9" "BC848B_SOT23-3_BC848B_" "SOT23-3" "IC" "IC") list("Q17" "BC848B_SOT23-3_BC848B_" "SOT23-3" "IC" "IC") list("Q16" "BC848B_SOT23-3_BC848B_" "SOT23-3" "IC" "IC") list("Q5" "BC848B_SOT23-3_BC848B_" "SOT23-3" "IC" "IC") list("Q8" "BC848B_SOT23-3_BC848B_" "SOT23-3" "IC" "IC") list("QB2" "BC848B_SOT23-3_BC848B_" "SOT23-3" "IC" "IC") list("Q13" "BC848B_SOT23-3_BC848B_" "SOT23-3" "IC" "IC") list("Q25" "BC848B_SOT23-3_BC848B_" "SOT23-3" "IC" "IC") list("Q23" "BC848B_SOT23-3_BC848B_" "SOT23-3" "IC" "IC") list("E2" "C_ELEC_E7343_NC_EEFSX0D331XE" "E7343" "IC" "IC") list("E1" "C_ELEC_E7343_NC_EEFSX0D331XE" "E7343" "IC" "IC") list("R221" "R_R0402_NC_47K/0402/1%_" "R0402_PC" "IC" "IC") list("R101" "R_R0402_1M/0402/1%_" "R0402_PC" "IC" "IC") list("RB30" "R_R0402_1M/0402/1%_" "R0402_PC" "IC" "IC") list("RB28" "R_R0402_1M/0402/1%_" "R0402_PC" "IC" "IC") list("R108" "R_R0402_1M/0402/1%_" "R0402_PC" "IC" "IC") list("RT41" "R_R0402_1M/0402/1%_" "R0402_PC" "IC" "IC") list("R97" "R_R0402_33R/0402/1%_" "R0402_PC" "DISCRETE" "DISCRETE") list("R96" "R_R0402_33R/0402/1%_" "R0402_PC" "DISCRETE" "DISCRETE") list("RB32" "R_R0402_33R/0402/1%_" "R0402_PC" "DISCRETE" "DISCRETE") list("RB21" "R_R0402_33R/0402/1%_" "R0402_PC" "DISCRETE" "DISCRETE") list("RB33" "R_R0402_33R/0402/1%_" "R0402_PC" "DISCRETE" "DISCRETE") list("R22" "R_R0402_33R/0402/1%_" "R0402_PC" "DISCRETE" "DISCRETE") list("R239" "R_R0402_33R/0402/1%_" "R0402_PC" "DISCRETE" "DISCRETE") list("R12" "R_R0402_33R/0402/1%_" "R0402_PC" "DISCRETE" "DISCRETE") list("R14" "R_R0402_33R/0402/1%_" "R0402_PC" "DISCRETE" "DISCRETE") list("R16" "R_R0402_33R/0402/1%_" "R0402_PC" "DISCRETE" "DISCRETE") list("R18" "R_R0402_33R/0402/1%_" "R0402_PC" "DISCRETE" "DISCRETE") list("R68" "R_R0402_33R/0402/1%_" "R0402_PC" "DISCRETE" "DISCRETE") list("R69" "R_R0402_33R/0402/1%_" "R0402_PC" "DISCRETE" "DISCRETE") list("R72" "R_R0402_33R/0402/1%_" "R0402_PC" "DISCRETE" "DISCRETE") list("R74" "R_R0402_33R/0402/1%_" "R0402_PC" "DISCRETE" "DISCRETE") list("R124" "R_R0402_33R/0402/1%_" "R0402_PC" "DISCRETE" "DISCRETE") list("R255" "R_R0402_33R/0402/1%_" "R0402_PC" "DISCRETE" "DISCRETE") list("R268" "R_R0402_33R/0402/1%_" "R0402_PC" "DISCRETE" "DISCRETE") list("R269" "R_R0402_33R/0402/1%_" "R0402_PC" "DISCRETE" "DISCRETE") list("R270" "R_R0402_33R/0402/1%_" "R0402_PC" "DISCRETE" "DISCRETE") list("R271" "R_R0402_33R/0402/1%_" "R0402_PC" "DISCRETE" "DISCRETE") list("R257" "R_R0402_33R/0402/1%_" "R0402_PC" "DISCRETE" "DISCRETE") list("R258" "R_R0402_33R/0402/1%_" "R0402_PC" "DISCRETE" "DISCRETE") list("R253" "R_R0402_33R/0402/1%_" "R0402_PC" "DISCRETE" "DISCRETE") list("R254" "R_R0402_33R/0402/1%_" "R0402_PC" "DISCRETE" "DISCRETE") list("R283" "R_R0402_33R/0402/1%_" "R0402_PC" "DISCRETE" "DISCRETE") list("RB42" "R_R0402_33R/0402/1%_" "R0402_PC" "DISCRETE" "DISCRETE") list("RB17" "R_R0402_33R/0402/1%_" "R0402_PC" "DISCRETE" "DISCRETE") list("RB16" "R_R0402_33R/0402/1%_" "R0402_PC" "DISCRETE" "DISCRETE") list("RB18" "R_R0402_33R/0402/1%_" "R0402_PC" "DISCRETE" "DISCRETE") list("RB19" "R_R0402_33R/0402/1%_" "R0402_PC" "DISCRETE" "DISCRETE") list("R245" "R_R0402_33R/0402/1%_" "R0402_PC" "DISCRETE" "DISCRETE") list("R251" "R_R0402_33R/0402/1%_" "R0402_PC" "DISCRETE" "DISCRETE") list("R267" "R_R0402_33R/0402/1%_" "R0402_PC" "DISCRETE" "DISCRETE") list("R264" "R_R0402_33R/0402/1%_" "R0402_PC" "DISCRETE" "DISCRETE") list("R115" "R_R0402_33R/0402/1%_" "R0402_PC" "DISCRETE" "DISCRETE") list("R123" "R_R0402_33R/0402/1%_" "R0402_PC" "DISCRETE" "DISCRETE") list("RT105" "R_R0402_33R/0402/1%_" "R0402_PC" "DISCRETE" "DISCRETE") list("RT104" "R_R0402_33R/0402/1%_" "R0402_PC" "DISCRETE" "DISCRETE") list("RT103" "R_R0402_33R/0402/1%_" "R0402_PC" "DISCRETE" "DISCRETE") list("RT102" "R_R0402_33R/0402/1%_" "R0402_PC" "DISCRETE" "DISCRETE") list("RT101" "R_R0402_33R/0402/1%_" "R0402_PC" "DISCRETE" "DISCRETE") list("RT100" "R_R0402_33R/0402/1%_" "R0402_PC" "DISCRETE" "DISCRETE") list("RB60" "R_R0402_33R/0402/1%_" "R0402_PC" "DISCRETE" "DISCRETE") list("RB59" "R_R0402_33R/0402/1%_" "R0402_PC" "DISCRETE" "DISCRETE") list("RB58" "R_R0402_33R/0402/1%_" "R0402_PC" "DISCRETE" "DISCRETE") list("RB57" "R_R0402_33R/0402/1%_" "R0402_PC" "DISCRETE" "DISCRETE") list("RB56" "R_R0402_33R/0402/1%_" "R0402_PC" "DISCRETE" "DISCRETE") list("RB55" "R_R0402_33R/0402/1%_" "R0402_PC" "DISCRETE" "DISCRETE") list("R104" "R_R0402_NC_33R/0402/1%_" "R0402_PC" "IC" "IC") list("R232" "R_R0402_NC_33R/0402/1%_" "R0402_PC" "IC" "IC") list("R129" "R_R0402_NC_33R/0402/1%_" "R0402_PC" "IC" "IC") list("D26" "PESD_R0402_ESD3E1G5BF" "R0402_PC" "IC" "IC") list("D27" "PESD_R0402_ESD3E1G5BF" "R0402_PC" "IC" "IC") list("D7" "PESD_R0402_ESD3E1G5BF" "R0402_PC" "IC" "IC") list("D28" "PESD_R0402_ESD3E1G5BF" "R0402_PC" "IC" "IC") list("D29" "PESD_R0402_ESD3E1G5BF" "R0402_PC" "IC" "IC") list("D21" "PESD_R0402_ESD3E1G5BF" "R0402_PC" "IC" "IC") list("D22" "PESD_R0402_ESD3E1G5BF" "R0402_PC" "IC" "IC") list("D23" "PESD_R0402_ESD3E1G5BF" "R0402_PC" "IC" "IC") list("D24" "PESD_R0402_ESD3E1G5BF" "R0402_PC" "IC" "IC") list("D8" "PESD_R0402_ESD3E1G5BF" "R0402_PC" "IC" "IC") list("D25" "PESD_R0402_ESD3E1G5BF" "R0402_PC" "IC" "IC") list("DT7" "PESD_R0402_ESD3E1G5BF" "R0402_PC" "IC" "IC") list("DT50" "PESD_R0402_ESD3E1G5BF" "R0402_PC" "IC" "IC") list("DT30" "PESD_R0402_ESD3E1G5BF" "R0402_PC" "IC" "IC") list("DT28" "PESD_R0402_ESD3E1G5BF" "R0402_PC" "IC" "IC") list("DT29" "PESD_R0402_ESD3E1G5BF" "R0402_PC" "IC" "IC") list("DT8" "PESD_R0402_ESD3E1G5BF" "R0402_PC" "IC" "IC") list("DT58" "PESD_R0402_ESD3E1G5BF" "R0402_PC" "IC" "IC") list("DT36" "PESD_R0402_ESD3E1G5BF" "R0402_PC" "IC" "IC") list("DT14" "PESD_R0402_ESD3E1G5BF" "R0402_PC" "IC" "IC") list("DT11" "PESD_R0402_ESD3E1G5BF" "R0402_PC" "IC" "IC") list("DT9" "PESD_R0402_ESD3E1G5BF" "R0402_PC" "IC" "IC") list("DT12" "PESD_R0402_ESD3E1G5BF" "R0402_PC" "IC" "IC") list("DT33" "PESD_R0402_ESD3E1G5BF" "R0402_PC" "IC" "IC") list("DT31" "PESD_R0402_ESD3E1G5BF" "R0402_PC" "IC" "IC") list("DT24" "PESD_R0402_ESD3E1G5BF" "R0402_PC" "IC" "IC") list("DT18" "PESD_R0402_ESD3E1G5BF" "R0402_PC" "IC" "IC") list("DT32" "PESD_R0402_ESD3E1G5BF" "R0402_PC" "IC" "IC") list("DT53" "PESD_R0402_ESD3E1G5BF" "R0402_PC" "IC" "IC") list("DT23" "PESD_R0402_ESD3E1G5BF" "R0402_PC" "IC" "IC") list("DT26" "PESD_R0402_ESD3E1G5BF" "R0402_PC" "IC" "IC") list("DT13" "PESD_R0402_ESD3E1G5BF" "R0402_PC" "IC" "IC") list("DT52" "PESD_R0402_ESD3E1G5BF" "R0402_PC" "IC" "IC") list("DT41" "PESD_R0402_ESD3E1G5BF" "R0402_PC" "IC" "IC") list("DT49" "PESD_R0402_ESD3E1G5BF" "R0402_PC" "IC" "IC") list("DT56" "PESD_R0402_ESD3E1G5BF" "R0402_PC" "IC" "IC") list("DT42" "PESD_R0402_ESD3E1G5BF" "R0402_PC" "IC" "IC") list("DT55" "PESD_R0402_ESD3E1G5BF" "R0402_PC" "IC" "IC") list("DT39" "PESD_R0402_ESD3E1G5BF" "R0402_PC" "IC" "IC") list("DT10" "PESD_R0402_ESD3E1G5BF" "R0402_PC" "IC" "IC") list("DT54" "PESD_R0402_ESD3E1G5BF" "R0402_PC" "IC" "IC") list("DT40" "PESD_R0402_ESD3E1G5BF" "R0402_PC" "IC" "IC") list("DT51" "PESD_R0402_ESD3E1G5BF" "R0402_PC" "IC" "IC") list("DT37" "PESD_R0402_ESD3E1G5BF" "R0402_PC" "IC" "IC") list("DT38" "PESD_R0402_ESD3E1G5BF" "R0402_PC" "IC" "IC") list("DT27" "PESD_R0402_ESD3E1G5BF" "R0402_PC" "IC" "IC") list("DT1" "PESD_R0402_ESD3E1G5BF" "R0402_PC" "IC" "IC") list("DT2" "PESD_R0402_ESD3E1G5BF" "R0402_PC" "IC" "IC") list("DT3" "PESD_R0402_ESD3E1G5BF" "R0402_PC" "IC" "IC") list("DT4" "PESD_R0402_ESD3E1G5BF" "R0402_PC" "IC" "IC") list("DT5" "PESD_R0402_ESD3E1G5BF" "R0402_PC" "IC" "IC") list("DT6" "PESD_R0402_ESD3E1G5BF" "R0402_PC" "IC" "IC") list("DT21" "PESD_R0402_ESD3E1G5BF" "R0402_PC" "IC" "IC") list("DT25" "PESD_R0402_ESD3E1G5BF" "R0402_PC" "IC" "IC") list("DT34" "PESD_R0402_ESD3E1G5BF" "R0402_PC" "IC" "IC") list("DT35" "PESD_R0402_ESD3E1G5BF" "R0402_PC" "IC" "IC") list("DT22" "PESD_R0402_ESD3E1G5BF" "R0402_PC" "IC" "IC") list("DT20" "PESD_R0402_ESD3E1G5BF" "R0402_PC" "IC" "IC") list("DT60" "PESD_R0402_ESD3E1G5BF" "R0402_PC" "IC" "IC") list("DT59" "PESD_R0402_ESD3E1G5BF" "R0402_PC" "IC" "IC") list("DT62" "PESD_R0402_ESD3E1G5BF" "R0402_PC" "IC" "IC") list("DT61" "PESD_R0402_ESD3E1G5BF" "R0402_PC" "IC" "IC") list("C377" "CAP_C0402_NC_12PF_" "C0402_PC" "IC" "IC") list("C2" "CAP_C0603_10UF/0603/16V/20%_" "C0603_PC" "DISCRETE" "DISCRETE") list("CT74" "CAP_C0603_10UF/0603/16V/20%_" "C0603_PC" "DISCRETE" "DISCRETE") list("CT78" "CAP_C0603_10UF/0603/16V/20%_" "C0603_PC" "DISCRETE" "DISCRETE") list("CB3" "CAP_C0603_10UF/0603/16V/20%_" "C0603_PC" "DISCRETE" "DISCRETE") list("CB23" "CAP_C0603_10UF/0603/16V/20%_" "C0603_PC" "DISCRETE" "DISCRETE") list("C367" "CAP_C0603_10UF/0603/16V/20%_" "C0603_PC" "DISCRETE" "DISCRETE") list("C175" "CAP_C0603_10UF/0603/16V/20%_" "C0603_PC" "DISCRETE" "DISCRETE") list("C176" "CAP_C0603_10UF/0603/16V/20%_" "C0603_PC" "DISCRETE" "DISCRETE") list("UT4" "MP6543H_QFN24_L3XH4_MP6543HGL-Z" "QFN24_L3XH4" "IC" "IC") list("UT3" "MP6543H_QFN24_L3XH4_MP6543HGL-Z" "QFN24_L3XH4" "IC" "IC") list("RT32" "R_R0402_150K/0402/1%_" "R0402_PC" "IC" "IC") list("RT22" "R_R0402_1M/0402/1%_000000000041" "R0402_PC" "IC" "IC") list("RT40" "R_0_R0402_NC_3.3R/0402/1%_" "R0402_PC" "IC" "IC") list("RT39" "R_0_R0402_NC_3.3R/0402/1%_" "R0402_PC" "IC" "IC") list("R67" "R_R0402_NC_4.7K/0402/1%_" "R0402_PC" "IC" "IC") list("R244" "R_R0402_NC_4.7K/0402/1%_" "R0402_PC" "IC" "IC") list("R185" "R_R0402_NC_4.7K/0402/1%_" "R0402_PC" "IC" "IC") list("R246" "R_R0402_NC_4.7K/0402/1%_" "R0402_PC" "IC" "IC") list("R247" "R_R0402_NC_4.7K/0402/1%_" "R0402_PC" "IC" "IC") list("R77" "R_R0402_NC_4.7K/0402/1%_" "R0402_PC" "IC" "IC") list("R78" "R_R0402_NC_4.7K/0402/1%_" "R0402_PC" "IC" "IC") list("R49" "R_R0402_NC_4.7K/0402/1%_" "R0402_PC" "IC" "IC") list("R52" "R_R0402_NC_4.7K/0402/1%_" "R0402_PC" "IC" "IC") list("RT70" "R_R1206_15R/1206/1%_" "R1206_PC" "DISCRETE" "DISCRETE") list("RT3" "R_R1206_15R/1206/1%_" "R1206_PC" "DISCRETE" "DISCRETE") list("RT35" "R_R0402_2R/0402/1%_" "R0402_PC" "IC" "IC") list("RT34" "R_R0402_2R/0402/1%_" "R0402_PC" "IC" "IC") list("RT10" "R_R0402_2R/0402/1%_" "R0402_PC" "IC" "IC") list("RT8" "R_R0402_2R/0402/1%_" "R0402_PC" "IC" "IC") list("RT43" "R_R0402_5.1K/0402/1%_" "R0402_PC" "DISCRETE" "DISCRETE") list("RT44" "R_R0402_5.1K/0402/1%_" "R0402_PC" "DISCRETE" "DISCRETE") list("RT45" "R_R0402_5.1K/0402/1%_" "R0402_PC" "DISCRETE" "DISCRETE") list("RT46" "R_R0402_5.1K/0402/1%_" "R0402_PC" "DISCRETE" "DISCRETE") list("RT47" "R_R0402_5.1K/0402/1%_" "R0402_PC" "DISCRETE" "DISCRETE") list("RT48" "R_R0402_5.1K/0402/1%_" "R0402_PC" "DISCRETE" "DISCRETE") list("RT13" "R_R0402_5.1K/0402/1%_" "R0402_PC" "DISCRETE" "DISCRETE") list("RT15" "R_R0402_15K/0402/1%_" "R0402_PC" "IC" "IC") list("RT68" "R_R0402_4.99K/0402/1%_" "R0402_PC" "DISCRETE" "DISCRETE") list("RT63" "R_R0402_4.99K/0402/1%_" "R0402_PC" "DISCRETE" "DISCRETE") list("RT54" "R_R0402_4.99K/0402/1%_" "R0402_PC" "DISCRETE" "DISCRETE") list("RT64" "R_R0402_4.99K/0402/1%_" "R0402_PC" "DISCRETE" "DISCRETE") list("RT53" "R_R0402_4.99K/0402/1%_" "R0402_PC" "DISCRETE" "DISCRETE") list("RT56" "R_R0402_4.99K/0402/1%_" "R0402_PC" "DISCRETE" "DISCRETE") list("RT57" "R_R0402_4.99K/0402/1%_" "R0402_PC" "DISCRETE" "DISCRETE") list("RT58" "R_R0402_4.99K/0402/1%_" "R0402_PC" "DISCRETE" "DISCRETE") list("RT59" "R_R0402_4.99K/0402/1%_" "R0402_PC" "DISCRETE" "DISCRETE") list("RT60" "R_R0402_4.99K/0402/1%_" "R0402_PC" "DISCRETE" "DISCRETE") list("RT61" "R_R0402_4.99K/0402/1%_" "R0402_PC" "DISCRETE" "DISCRETE") list("RT62" "R_R0402_4.99K/0402/1%_" "R0402_PC" "DISCRETE" "DISCRETE") list("R2" "R_R0402_20K/0402/1%_" "R0402_PC" "DISCRETE" "DISCRETE") list("R5" "R_R0402_20K/0402/1%_" "R0402_PC" "DISCRETE" "DISCRETE") list("RT90" "R_R0402_20K/0402/1%_" "R0402_PC" "DISCRETE" "DISCRETE") list("RT37" "R_R1206_20MR/1206/1%_" "R1206_PC" "IC" "IC") list("RT38" "R_R1206_20MR/1206/1%_" "R1206_PC" "IC" "IC") list("RB27" "R_R0402_NC_10K/0402/1%_" "R0402_PC" "IC" "IC") list("R131" "R_R0402_NC_10K/0402/1%_" "R0402_PC" "IC" "IC") list("RT16" "R_R0402_NC_0R/0402/1%_" "R0402_PC" "IC" "IC") list("RB40" "R_R0402_NC_0R/0402/1%_" "R0402_PC" "IC" "IC") list("R272" "R_R0402_NC_0R/0402/1%_" "R0402_PC" "IC" "IC") list("RB52" "R_R0402_NC_0R/0402/1%_" "R0402_PC" "IC" "IC") list("RB10" "R_R0402_NC_0R/0402/1%_" "R0402_PC" "IC" "IC") list("RB11" "R_R0402_NC_0R/0402/1%_" "R0402_PC" "IC" "IC") list("R50" "R_R0402_NC_0R/0402/1%_" "R0402_PC" "IC" "IC") list("R47" "R_R0402_NC_0R/0402/1%_" "R0402_PC" "IC" "IC") list("RB6" "R_R0402_NC_0R/0402/1%_" "R0402_PC" "IC" "IC") list("RB9" "R_R0402_NC_0R/0402/1%_" "R0402_PC" "IC" "IC") list("R73" "R_R0402_NC_0R/0402/1%_" "R0402_PC" "IC" "IC") list("R286" "R_R0402_NC_0R/0402/1%_" "R0402_PC" "IC" "IC") list("QT2" "BC848B_SOT23-3_BC848B_170000002" "SOT23-3" "IC" "IC") list("QT1" "BC848B_SOT23-3_BC848B_170000002" "SOT23-3" "IC" "IC") list("FBT1" "CD42-2R2UH_L1206_CVB3216E101T" "L1206_PC" "IC" "IC") list("FBT2" "CD42-2R2UH_L1206_CVB3216E101T" "L1206_PC" "IC" "IC") list("DT17" "PESD_R0402_ESD3BD3G0BF" "R0402_PC" "IC" "IC") list("DT19" "PESD_R0402_ESD3BD3G0BF" "R0402_PC" "IC" "IC") list("CT50" "CAP_C0402_NC_1NF/0402/50V/10%_" "C0402_PC" "DISCRETE" "DISCRETE") list("CT51" "CAP_C0402_NC_1NF/0402/50V/10%_" "C0402_PC" "DISCRETE" "DISCRETE") list("CT70" "CAP_C0402_NC_1NF/0402/50V/10%_" "C0402_PC" "DISCRETE" "DISCRETE") list("CT44" "CAP_C0402_1NF/0402/50V/10%_" "C0402_PC" "DISCRETE" "DISCRETE") list("CT45" "CAP_C0402_1NF/0402/50V/10%_" "C0402_PC" "DISCRETE" "DISCRETE") list("CT55" "CAP_C0402_1NF/0402/50V/10%_" "C0402_PC" "DISCRETE" "DISCRETE") list("CT56" "CAP_C0402_1NF/0402/50V/10%_" "C0402_PC" "DISCRETE" "DISCRETE") list("CT132" "CAP_C0402_1NF/0402/50V/10%_" "C0402_PC" "DISCRETE" "DISCRETE") list("CT117" "CAP_C0402_1NF/0402/50V/10%_" "C0402_PC" "DISCRETE" "DISCRETE") list("CT30" "CAP_C0402_47NF/0402/16V/10%_" "C0402_PC" "IC" "IC") list("CT39" "CAP_C0402_47NF/0402/16V/10%_" "C0402_PC" "IC" "IC") list("CT19" "CAP_C0402_10NF/0402/16V/10%_" "C0402_PC" "IC" "DISCRETE") list("CT27" "CAP_C0402_10NF/0402/16V/10%_" "C0402_PC" "IC" "DISCRETE") list("CT15" "CAP_C0402_10NF/0402/16V/10%_" "C0402_PC" "IC" "DISCRETE") list("CT40" "CAP_0_C0402_NC_10NF/0402_" "C0402_PC" "IC" "IC") list("CT25" "CAP_0_C0402_NC_10NF/0402_" "C0402_PC" "IC" "IC") list("CT69" "CAP_C0603_4.7UF/0603/25V/10%_" "C0603_PC" "DISCRETE" "DISCRETE") list("CT68" "CAP_C0603_4.7UF/0603/25V/10%_" "C0603_PC" "DISCRETE" "DISCRETE") list("CT41" "CAP_0_C0402_1NF/0402/50V/10%_" "C0402_PC" "IC" "IC") list("CT26" "CAP_0_C0402_1NF/0402/50V/10%_" "C0402_PC" "IC" "IC") list("CT72" "CAP_C0603_1UF/0603/25V/10%_" "C0603_PC" "DISCRETE" "DISCRETE") list("CT77" "CAP_C0603_1UF/0603/25V/10%_" "C0603_PC" "DISCRETE" "DISCRETE") list("CT75" "CAP_C0603_1UF/0603/25V/10%_" "C0603_PC" "DISCRETE" "DISCRETE") list("CT73" "CAP_C0603_1UF/0603/25V/10%_" "C0603_PC" "DISCRETE" "DISCRETE") list("CT13" "CAP_C0603_1UF/0603/25V/10%_" "C0603_PC" "DISCRETE" "DISCRETE") list("CT46" "CAP_C0603_2.2UF/0603/25V/10%_" "C0603_PC" "DISCRETE" "DISCRETE") list("CT54" "CAP_C0603_2.2UF/0603/25V/10%_" "C0603_PC" "DISCRETE" "DISCRETE") list("CB25" "CAP_C0402_10PF/0402/50V/5%_" "C0402_PC" "DISCRETE" "DISCRETE") list("C104" "CAP_C0402_10PF/0402/50V/5%_" "C0402_PC" "DISCRETE" "DISCRETE") list("C102" "CAP_C0402_10PF/0402/50V/5%_" "C0402_PC" "DISCRETE" "DISCRETE") list("CT71" "CAP_C0402_100NF/0402/25V/10%_" "C0402_PC" "DISCRETE" "DISCRETE") list("CT24" "CAP_C0402_100NF/0402/25V/10%_" "C0402_PC" "DISCRETE" "DISCRETE") list("CT14" "CAP_C0402_100NF/0402/25V/10%_" "C0402_PC" "DISCRETE" "DISCRETE") list("CT103" "CAP_C0402_100NF/0402/25V/10%_" "C0402_PC" "DISCRETE" "DISCRETE") list("CT16" "CAP_C0402_100NF/0402/25V/10%_" "C0402_PC" "DISCRETE" "DISCRETE") list("CT22" "CAP_C0402_100NF/0402/25V/10%_" "C0402_PC" "DISCRETE" "DISCRETE") list("CT42" "CAP_C0402_100NF/0402/25V/10%_" "C0402_PC" "DISCRETE" "DISCRETE") list("CT29" "CAP_C0402_100NF/0402/25V/10%_" "C0402_PC" "DISCRETE" "DISCRETE") list("CT79" "CAP_C0402_100NF/0402/25V/10%_" "C0402_PC" "DISCRETE" "DISCRETE") list("CT17" "CAP_C0402_100NF/0402/25V/10%_" "C0402_PC" "DISCRETE" "DISCRETE") list("CT104" "CAP_C0402_100NF/0402/25V/10%_" "C0402_PC" "DISCRETE" "DISCRETE") list("CT7" "CAP_C0402_100NF/0402/25V/10%_" "C0402_PC" "DISCRETE" "DISCRETE") list("CT11" "CAP_C0402_100NF/0402/25V/10%_" "C0402_PC" "DISCRETE" "DISCRETE") list("CT76" "CAP_C0402_100NF/0402/25V/10%_" "C0402_PC" "DISCRETE" "DISCRETE") list("CT10" "CAP_C0402_100NF/0402/25V/10%_" "C0402_PC" "DISCRETE" "DISCRETE") list("CT80" "CAP_C0402_100NF/0402/25V/10%_" "C0402_PC" "DISCRETE" "DISCRETE") list("CB16" "CAP_C0402_100NF/0402/25V/10%_" "C0402_PC" "DISCRETE" "DISCRETE") list("CB9" "CAP_C0402_100NF/0402/25V/10%_" "C0402_PC" "DISCRETE" "DISCRETE") list("CB5" "CAP_C0402_100NF/0402/25V/10%_" "C0402_PC" "DISCRETE" "DISCRETE") list("CB2" "CAP_C0402_100NF/0402/25V/10%_" "C0402_PC" "DISCRETE" "DISCRETE") list("CT2" "CAP_C0402_100NF/0402/25V/10%_" "C0402_PC" "DISCRETE" "DISCRETE") list("CB1" "CAP_C0402_100NF/0402/25V/10%_" "C0402_PC" "DISCRETE" "DISCRETE") list("C103" "CAP_C0402_100NF/0402/25V/10%_" "C0402_PC" "DISCRETE" "DISCRETE") list("C96" "CAP_C0402_100NF/0402/25V/10%_" "C0402_PC" "DISCRETE" "DISCRETE") list("C59" "CAP_C0402_100NF/0402/25V/10%_" "C0402_PC" "DISCRETE" "DISCRETE") list("C85" "CAP_C0402_100NF/0402/25V/10%_" "C0402_PC" "DISCRETE" "DISCRETE") list("C179" "CAP_C0402_100NF/0402/25V/10%_" "C0402_PC" "DISCRETE" "DISCRETE") list("C48" "CAP_C0402_100NF/0402/25V/10%_" "C0402_PC" "DISCRETE" "DISCRETE") list("C8" "CAP_C0402_100NF/0402/25V/10%_" "C0402_PC" "DISCRETE" "DISCRETE") list("C364" "CAP_C0402_100NF/0402/25V/10%_" "C0402_PC" "DISCRETE" "DISCRETE") list("C12" "CAP_C0402_100NF/0402/25V/10%_" "C0402_PC" "DISCRETE" "DISCRETE") list("C1" "CAP_C0402_100NF/0402/25V/10%_" "C0402_PC" "DISCRETE" "DISCRETE") list("C110" "CAP_C0402_100NF/0402/25V/10%_" "C0402_PC" "DISCRETE" "DISCRETE") list("C144" "CAP_C0402_100NF/0402/25V/10%_" "C0402_PC" "DISCRETE" "DISCRETE") list("C182" "CAP_C0402_100NF/0402/25V/10%_" "C0402_PC" "DISCRETE" "DISCRETE") list("C198" "CAP_C0402_100NF/0402/25V/10%_" "C0402_PC" "DISCRETE" "DISCRETE") list("C233" "CAP_C0402_100NF/0402/25V/10%_" "C0402_PC" "DISCRETE" "DISCRETE") list("C361" "CAP_C0402_100NF/0402/25V/10%_" "C0402_PC" "DISCRETE" "DISCRETE") list("C165" "CAP_C0402_100NF/0402/25V/10%_" "C0402_PC" "DISCRETE" "DISCRETE") list("C358" "CAP_C0402_100NF/0402/25V/10%_" "C0402_PC" "DISCRETE" "DISCRETE") list("C352" "CAP_C0402_100NF/0402/25V/10%_" "C0402_PC" "DISCRETE" "DISCRETE") list("C174" "CAP_C0402_100NF/0402/25V/10%_" "C0402_PC" "DISCRETE" "DISCRETE") list("C168" "CAP_C0402_100NF/0402/25V/10%_" "C0402_PC" "DISCRETE" "DISCRETE") list("C40" "CAP_C0402_100NF/0402/25V/10%_" "C0402_PC" "DISCRETE" "DISCRETE") list("C379" "CAP_C0402_100NF/0402/25V/10%_" "C0402_PC" "DISCRETE" "DISCRETE") list("C192" "CAP_C0402_100NF/0402/25V/10%_" "C0402_PC" "DISCRETE" "DISCRETE") list("C193" "CAP_C0402_100NF/0402/25V/10%_" "C0402_PC" "DISCRETE" "DISCRETE") list("C196" "CAP_C0402_100NF/0402/25V/10%_" "C0402_PC" "DISCRETE" "DISCRETE") list("C145" "CAP_C0402_100NF/0402/25V/10%_" "C0402_PC" "DISCRETE" "DISCRETE") list("C7" "CAP_C0402_100NF/0402/25V/10%_" "C0402_PC" "DISCRETE" "DISCRETE") list("CT125" "CAP_C0402_100NF/0402/25V/10%_" "C0402_PC" "DISCRETE" "DISCRETE") list("CT120" "CAP_C0402_100NF/0402/25V/10%_" "C0402_PC" "DISCRETE" "DISCRETE") list("CT119" "CAP_C0402_100NF/0402/25V/10%_" "C0402_PC" "DISCRETE" "DISCRETE") list("CB8" "CAP_C0805_22UF/0805/16V/20%_" "C0805_PC" "IC" "IC") list("CB7" "CAP_C0805_22UF/0805/16V/20%_" "C0805_PC" "IC" "IC") list("CB6" "CAP_C0805_22UF/0805/16V/20%_" "C0805_PC" "IC" "IC") list("CB24" "CAP_C0402_2.2UF/0402/6.3V/10%_" "C0402_PC" "DISCRETE" "DISCRETE") list("C9" "CAP_C0805_22UF/0805/6.3V/20%_" "C0805_PC" "IC" "IC") list("C11" "CAP_C0805_22UF/0805/6.3V/20%_" "C0805_PC" "IC" "IC") list("C10" "CAP_C0805_22UF/0805/6.3V/20%_" "C0805_PC" "IC" "IC") list("C124" "CAP2_C0603_10UF/0603/6.3V/10%" "C0603_PC" "IC" "IC") list("C100" "CAP2_C0603_10UF/0603/6.3V/10%" "C0603_PC" "IC" "IC") list("C63" "CAP2_C0603_10UF/0603/6.3V/10%" "C0603_PC" "IC" "IC") list("C88" "CAP2_C0603_10UF/0603/6.3V/10%" "C0603_PC" "IC" "IC") list("C36" "CAP2_C0603_10UF/0603/6.3V/10%" "C0603_PC" "IC" "IC") list("C330" "CAP2_C0603_10UF/0603/6.3V/10%" "C0603_PC" "IC" "IC") list("C334" "CAP2_C0603_10UF/0603/6.3V/10%" "C0603_PC" "IC" "IC") list("C280" "CAP2_C0603_10UF/0603/6.3V/10%" "C0603_PC" "IC" "IC") list("C267" "CAP2_C0603_10UF/0603/6.3V/10%" "C0603_PC" "IC" "IC") list("C212" "CAP2_C0603_10UF/0603/6.3V/10%" "C0603_PC" "IC" "IC") list("C67" "CAP2_C0603_10UF/0603/6.3V/10%" "C0603_PC" "IC" "IC") list("C199" "CAP2_C0603_10UF/0603/6.3V/10%" "C0603_PC" "IC" "IC") list("C185" "CAP2_C0603_10UF/0603/6.3V/10%" "C0603_PC" "IC" "IC") list("C180" "CAP_C0603_10UF/0603/6.3V/10%_" "C0603_PC" "IC" "IC") list("C178" "CAP_C0603_10UF/0603/6.3V/10%_" "C0603_PC" "IC" "IC") list("C366" "CAP_C0603_10UF/0603/6.3V/10%_" "C0603_PC" "IC" "IC") list("C355" "CAP_C0603_10UF/0603/6.3V/10%_" "C0603_PC" "IC" "IC") list("RT52" "R_R0402_1.3K/0402/1%_" "R0402_PC" "DISCRETE" "DISCRETE") list("RT42" "R_R0402_1.3K/0402/1%_" "R0402_PC" "DISCRETE" "DISCRETE") list("U17" "CS8631_SOP10L-EP_CS8631" "SOP10L-EP" "IC" "IC") list("L4" "L_L444212_AUPI0420-2R2M_" "L444212" "IC" "IC") list("Q7" "PMOS_3PIN_SOT23-3_NCE3401AY" "SOT23-3" "IC" "IC") list("Q6" "PMOS_3PIN_SOT23-3_NCE3401AY" "SOT23-3" "IC" "IC") list("Q11" "PMOS_3PIN_SOT23-3_NCE3401AY" "SOT23-3" "IC" "IC") list("Q24" "PMOS_3PIN_SOT23-3_NCE3401AY" "SOT23-3" "IC" "IC") list("Q22" "PMOS_3PIN_SOT23-3_NCE3401AY" "SOT23-3" "IC" "IC") list("RT5" "R_R1206_10MR/1206/1%_" "R1206_PC" "IC" "IC") list("RT7" "R_R1206_10MR/1206/1%_" "R1206_PC" "IC" "IC") list("C262" "CAP2_C0402_100NF/0402/25V/10%" "C0402_PC" "IC" "IC") list("C206" "CAP2_C0402_100NF/0402/25V/10%" "C0402_PC" "IC" "IC") list("C205" "CAP2_C0402_100NF/0402/25V/10%" "C0402_PC" "IC" "IC") list("CB4" "CAP_C0402_22PF/0402/50V/5%_" "C0402_PC" "IC" "IC") list("C108" "CAP_C0402_100NF/0402/16V/10%_" "C0402_PC" "IC" "IC") list("C61" "CAP_C0402_100NF/0402/16V/10%_" "C0402_PC" "IC" "IC") list("C68" "CAP_C0402_100NF/0402/16V/10%_" "C0402_PC" "IC" "IC") list("C3" "CAP_C0402_100NF/0402/16V/10%_" "C0402_PC" "IC" "IC") list("C4" "CAP_C0402_100NF/0402/16V/10%_" "C0402_PC" "IC" "IC") list("C135" "CAP_C0402_100NF/0402/16V/10%_" "C0402_PC" "IC" "IC") list("C138" "CAP_C0402_100NF/0402/16V/10%_" "C0402_PC" "IC" "IC") list("C122" "CAP_C0402_100NF/0402/16V/10%_" "C0402_PC" "IC" "IC") list("C121" "CAP_C0402_100NF/0402/16V/10%_" "C0402_PC" "IC" "IC") list("C161" "CAP_C0402_100NF/0402/16V/10%_" "C0402_PC" "IC" "IC") list("C160" "CAP_C0402_100NF/0402/16V/10%_" "C0402_PC" "IC" "IC") list("C155" "CAP_C0402_100NF/0402/16V/10%_" "C0402_PC" "IC" "IC") list("C158" "CAP_C0402_100NF/0402/16V/10%_" "C0402_PC" "IC" "IC") list("C154" "CAP_C0402_100NF/0402/16V/10%_" "C0402_PC" "IC" "IC") list("C140" "CAP_C0402_100NF/0402/16V/10%_" "C0402_PC" "IC" "IC") list("C171" "CAP_C0402_100NF/0402/16V/10%_" "C0402_PC" "IC" "IC") list("C157" "CAP_C0402_100NF/0402/16V/10%_" "C0402_PC" "IC" "IC") list("C152" "CAP_C0402_100NF/0402/16V/10%_" "C0402_PC" "IC" "IC") list("C153" "CAP_C0402_100NF/0402/16V/10%_" "C0402_PC" "IC" "IC") list("C350" "CAP_C0402_100NF/0402/16V/10%_" "C0402_PC" "IC" "IC") list("C150" "CAP_C0402_100NF/0402/16V/10%_" "C0402_PC" "IC" "IC") list("C169" "CAP_C0402_100NF/0402/16V/10%_" "C0402_PC" "IC" "IC") list("C362" "CAP_C0402_100NF/0402/16V/10%_" "C0402_PC" "IC" "IC") list("C118" "CAP_C0402_100NF/0402/16V/10%_" "C0402_PC" "IC" "IC") list("C126" "CAP_C0402_100NF/0402/16V/10%_" "C0402_PC" "IC" "IC") list("C127" "CAP_C0402_100NF/0402/16V/10%_" "C0402_PC" "IC" "IC") list("C119" "CAP_C0402_100NF/0402/16V/10%_" "C0402_PC" "IC" "IC") list("C142" "CAP_C0402_100NF/0402/16V/10%_" "C0402_PC" "IC" "IC") list("C139" "CAP_C0402_100NF/0402/16V/10%_" "C0402_PC" "IC" "IC") list("C143" "CAP_C0402_100NF/0402/16V/10%_" "C0402_PC" "IC" "IC") list("C131" "CAP_C0402_100NF/0402/16V/10%_" "C0402_PC" "IC" "IC") list("C117" "CAP_C0402_100NF/0402/16V/10%_" "C0402_PC" "IC" "IC") list("C129" "CAP_C0402_100NF/0402/16V/10%_" "C0402_PC" "IC" "IC") list("C136" "CAP_C0402_100NF/0402/16V/10%_" "C0402_PC" "IC" "IC") list("C371" "CAP_C0402_100NF/0402/16V/10%_" "C0402_PC" "IC" "IC") list("C374" "CAP_C0402_100NF/0402/16V/10%_" "C0402_PC" "IC" "IC") list("C368" "CAP_C0402_100NF/0402/16V/10%_" "C0402_PC" "IC" "IC") list("C105" "CAP_C0402_100NF/0402/16V/10%_" "C0402_PC" "IC" "IC") list("C363" "CAP_C0402_100NF/0402/16V/10%_" "C0402_PC" "IC" "IC") list("RT6" "R_R1206_NC_0R/1206/1%_" "R1206_PC" "IC" "IC") list("TPT5" "TP-A_TPS-0D4_NC_TP_" "TPS-0D4" "IC" "IC") list("TPT6" "TP-A_TPS-0D5_NC_TP_" "TPS-0D5" "IC" "IC") list("TPT31" "TP-A_TPS-0D5_NC_TP_" "TPS-0D5" "IC" "IC") list("TPT38" "TP-A_TPS-0D5_NC_TP_" "TPS-0D5" "IC" "IC") list("TPB55" "TP-A_TPS-0D5_NC_TP_" "TPS-0D5" "IC" "IC") list("TPB56" "TP-A_TPS-0D5_NC_TP_" "TPS-0D5" "IC" "IC") list("TPB6" "TP-A_TPS-2D5_NC_TP_" "TPS-2D5" "IC" "IC") list("TP27" "TP_TPS-0D5_NC_TP" "TPS-0D5" "IC" "IC") list("TP39" "TP_TPS-0D5_NC_TP" "TPS-0D5" "IC" "IC") list("TP38" "TP_TPS-0D5_NC_TP" "TPS-0D5" "IC" "IC") list("TP36" "TP_TPS-0D5_NC_TP" "TPS-0D5" "IC" "IC") list("TPB2" "TP-A_TPS_0D8_0D9_NC_TP_" "TPS_0D8_0D9" "IC" "IC") list("TPB3" "TP-A_TPS_0D8_0D9_NC_TP_" "TPS_0D8_0D9" "IC" "IC") list("TPB1" "TP-A_TPS_0D8_0D9_NC_TP_" "TPS_0D8_0D9" "IC" "IC") list("TP2" "TP-A_TPS_0D8_0D9_NC_TP_" "TPS_0D8_0D9" "IC" "IC") list("TP54" "TP-A_TPS_0D8_0D9_NC_TP_" "TPS_0D8_0D9" "IC" "IC") list("TPT1" "TP-A_TPS1D0M1D2_NC_TP_" "TPS1D0M1D2" "IC" "IC") list("TPT2" "TP-A_TPS1D0M1D2_NC_TP_" "TPS1D0M1D2" "IC" "IC") list("TPT25" "TP-A_TPS1D0M1D2_NC_TP_" "TPS1D0M1D2" "IC" "IC") list("TPT4" "TP-A_TPS1D0M1D2_NC_TP_" "TPS1D0M1D2" "IC" "IC") list("TPT3" "TP-A_TPS1D0M1D2_NC_TP_" "TPS1D0M1D2" "IC" "IC") list("TPT45" "TP-A_TPS1D0M1D2_NC_TP_" "TPS1D0M1D2" "IC" "IC") list("TPT43" "TP-A_TPS1D0M1D2_NC_TP_" "TPS1D0M1D2" "IC" "IC") list("TPT42" "TP-A_TPS1D0M1D2_NC_TP_" "TPS1D0M1D2" "IC" "IC") list("TPT41" "TP-A_TPS1D0M1D2_NC_TP_" "TPS1D0M1D2" "IC" "IC") list("TPT8" "TP-A_TPS1D0M1D2_NC_TP_" "TPS1D0M1D2" "IC" "IC") list("TPT11" "TP-A_TPS1D0M1D2_NC_TP_" "TPS1D0M1D2" "IC" "IC") list("TPT44" "TP-A_TPS1D0M1D2_NC_TP_" "TPS1D0M1D2" "IC" "IC") list("TPT40" "TP-A_TPS1D0M1D2_NC_TP_" "TPS1D0M1D2" "IC" "IC") list("TPT26" "TP-A_TPS1D0M1D2_NC_TP_" "TPS1D0M1D2" "IC" "IC") list("TPT34" "TP-A_TPS1D0M1D2_NC_TP_" "TPS1D0M1D2" "IC" "IC") list("TPT27" "TP-A_TPS1D0M1D2_NC_TP_" "TPS1D0M1D2" "IC" "IC") list("TPT33" "TP-A_TPS1D0M1D2_NC_TP_" "TPS1D0M1D2" "IC" "IC") list("TPT10" "TP-A_TPS1D0M1D2_NC_TP_" "TPS1D0M1D2" "IC" "IC") list("TPB29" "TP-A_TPS1D0M1D2_NC_TP_" "TPS1D0M1D2" "IC" "IC") list("TPB12" "TP-A_TPS1D0M1D2_NC_TP_" "TPS1D0M1D2" "IC" "IC") list("TPB11" "TP-A_TPS1D0M1D2_NC_TP_" "TPS1D0M1D2" "IC" "IC") list("TPB54" "TP-A_TPS1D0M1D2_NC_TP_" "TPS1D0M1D2" "IC" "IC") list("TPB13" "TP-A_TPS1D0M1D2_NC_TP_" "TPS1D0M1D2" "IC" "IC") list("TPB14" "TP-A_TPS1D0M1D2_NC_TP_" "TPS1D0M1D2" "IC" "IC") list("TPB4" "TP-A_TPS1D0M1D2_NC_TP_" "TPS1D0M1D2" "IC" "IC") list("TPB30" "TP-A_TPS1D0M1D2_NC_TP_" "TPS1D0M1D2" "IC" "IC") list("TPB31" "TP-A_TPS1D0M1D2_NC_TP_" "TPS1D0M1D2" "IC" "IC") list("TPB52" "TP-A_TPS1D0M1D2_NC_TP_" "TPS1D0M1D2" "IC" "IC") list("TPB28" "TP-A_TPS1D0M1D2_NC_TP_" "TPS1D0M1D2" "IC" "IC") list("TPB33" "TP-A_TPS1D0M1D2_NC_TP_" "TPS1D0M1D2" "IC" "IC") list("TPB35" "TP-A_TPS1D0M1D2_NC_TP_" "TPS1D0M1D2" "IC" "IC") list("TPB37" "TP-A_TPS1D0M1D2_NC_TP_" "TPS1D0M1D2" "IC" "IC") list("TPB43" "TP-A_TPS1D0M1D2_NC_TP_" "TPS1D0M1D2" "IC" "IC") list("TPB39" "TP-A_TPS1D0M1D2_NC_TP_" "TPS1D0M1D2" "IC" "IC") list("TPB41" "TP-A_TPS1D0M1D2_NC_TP_" "TPS1D0M1D2" "IC" "IC") list("TPB9" "TP-A_TPS1D0M1D2_NC_TP_" "TPS1D0M1D2" "IC" "IC") list("TPB32" "TP-A_TPS1D0M1D2_NC_TP_" "TPS1D0M1D2" "IC" "IC") list("TPB34" "TP-A_TPS1D0M1D2_NC_TP_" "TPS1D0M1D2" "IC" "IC") list("TPB40" "TP-A_TPS1D0M1D2_NC_TP_" "TPS1D0M1D2" "IC" "IC") list("TPB21" "TP-A_TPS1D0M1D2_NC_TP_" "TPS1D0M1D2" "IC" "IC") list("TPB36" "TP-A_TPS1D0M1D2_NC_TP_" "TPS1D0M1D2" "IC" "IC") list("TPB25" "TP-A_TPS1D0M1D2_NC_TP_" "TPS1D0M1D2" "IC" "IC") list("TPB27" "TP-A_TPS1D0M1D2_NC_TP_" "TPS1D0M1D2" "IC" "IC") list("TPB49" "TP-A_TPS1D0M1D2_NC_TP_" "TPS1D0M1D2" "IC" "IC") list("TP81" "TP-A_TPS1D0M1D2_NC_TP_" "TPS1D0M1D2" "IC" "IC") list("TP51" "TP-A_TPS1D0M1D2_NC_TP_" "TPS1D0M1D2" "IC" "IC") list("TP48" "TP-A_TPS1D0M1D2_NC_TP_" "TPS1D0M1D2" "IC" "IC") list("TP52" "TP-A_TPS1D0M1D2_NC_TP_" "TPS1D0M1D2" "IC" "IC") list("TP40" "TP-A_TPS1D0M1D2_NC_TP_" "TPS1D0M1D2" "IC" "IC") list("TP44" "TP-A_TPS1D0M1D2_NC_TP_" "TPS1D0M1D2" "IC" "IC") list("TP30" "TP-A_TPS1D0M1D2_NC_TP_" "TPS1D0M1D2" "IC" "IC") list("TP107" "TP-A_TPS1D0M1D2_NC_TP_" "TPS1D0M1D2" "IC" "IC") list("TP106" "TP-A_TPS1D0M1D2_NC_TP_" "TPS1D0M1D2" "IC" "IC") list("TP65" "TP-A_TPS1D0M1D2_NC_TP_" "TPS1D0M1D2" "IC" "IC") list("TP58" "TP-A_TPS1D0M1D2_NC_TP_" "TPS1D0M1D2" "IC" "IC") list("TP108" "TP-A_TPS1D0M1D2_NC_TP_" "TPS1D0M1D2" "IC" "IC") list("TP31" "TP-MIN_TPS-0D5_NC_TP_" "TPS-0D5" "IC" "IC") list("TP32" "TP-MIN_TPS-0D5_NC_TP_" "TPS-0D5" "IC" "IC") list("TP61" "TP-MIN_TPS-0D5_NC_TP_" "TPS-0D5" "IC" "IC") list("TP60" "TP-MIN_TPS-0D5_NC_TP_" "TPS-0D5" "IC" "IC") list("TP47" "TP-MIN_TPS-0D5_NC_TP_" "TPS-0D5" "IC" "IC") list("TP6" "TP-MIN_TPS-0D5_NC_TP_" "TPS-0D5" "IC" "IC") list("TP16" "TP-MIN_TPS-0D5_NC_TP_" "TPS-0D5" "IC" "IC") list("TP117" "TP-MIN_TPS-0D5_NC_TP_" "TPS-0D5" "IC" "IC") list("TP127" "TP-MIN_TPS-0D5_NC_TP_" "TPS-0D5" "IC" "IC") list("TP128" "TP-MIN_TPS-0D5_NC_TP_" "TPS-0D5" "IC" "IC") list("TP131" "TP-MIN_TPS-0D5_NC_TP_" "TPS-0D5" "IC" "IC") list("TP118" "TP-MIN_TPS-0D5_NC_TP_" "TPS-0D5" "IC" "IC") list("TP50" "TP-MIN_TPS-0D5_NC_TP_" "TPS-0D5" "IC" "IC") list("TP129" "TP-MIN_TPS-0D5_NC_TP_" "TPS-0D5" "IC" "IC") list("TP110" "TP-MIN_TPS-0D5_NC_TP_" "TPS-0D5" "IC" "IC") list("TP130" "TP-MIN_TPS-0D5_NC_TP_" "TPS-0D5" "IC" "IC") list("TP109" "TP-MIN_TPS-0D5_NC_TP_" "TPS-0D5" "IC" "IC") list("TP17" "TP-MIN_TPS-0D5_NC_TP_" "TPS-0D5" "IC" "IC") list("TP20" "TP-MIN_TPS-0D5_NC_TP_" "TPS-0D5" "IC" "IC") list("TP18" "TP-MIN_TPS-0D5_NC_TP_" "TPS-0D5" "IC" "IC") list("TP19" "TP-MIN_TPS-0D5_NC_TP_" "TPS-0D5" "IC" "IC") list("TP114" "TP-MIN_TPS-0D5_NC_TP_" "TPS-0D5" "IC" "IC") list("TP8" "TP-MIN_TPS-0D5_NC_TP_" "TPS-0D5" "IC" "IC") list("TP15" "TP-MIN_TPS-0D5_NC_TP_" "TPS-0D5" "IC" "IC") list("TP7" "TP-MIN_TPS-0D5_NC_TP_" "TPS-0D5" "IC" "IC") list("TP5" "TP-MIN_TPS-0D5_NC_TP_" "TPS-0D5" "IC" "IC") list("TP13" "TP-MIN_TPS-0D5_NC_TP_" "TPS-0D5" "IC" "IC") list("TP124" "TP-MIN_TPS-0D5_NC_TP_" "TPS-0D5" "IC" "IC") list("TP123" "TP-MIN_TPS-0D5_NC_TP_" "TPS-0D5" "IC" "IC") list("TP121" "TP-MIN_TPS-0D5_NC_TP_" "TPS-0D5" "IC" "IC") list("TP120" "TP-MIN_TPS-0D5_NC_TP_" "TPS-0D5" "IC" "IC") list("TP12" "TP-MIN_TPS-0D5_NC_TP_" "TPS-0D5" "IC" "IC") list("TP93" "TP-A_TPS1D5_NC_TP_" "TPS1D5" "IC" "IC") list("TP84" "TP-A_TPS1D5_NC_TP_" "TPS1D5" "IC" "IC") list("TP89" "TP-A_TPS1D5_NC_TP_" "TPS1D5" "IC" "IC") list("TP103" "TP-A_TPS1D5_NC_TP_" "TPS1D5" "IC" "IC") list("TP87" "TP-A_TPS1D5_NC_TP_" "TPS1D5" "IC" "IC") list("TP119" "TP-A_TPS1D5_NC_TP_" "TPS1D5" "IC" "IC") list("TP67" "TP-A_TPS1D5_NC_TP_" "TPS1D5" "IC" "IC") list("TP100" "TP-A_TPS1D5_NC_TP_" "TPS1D5" "IC" "IC") list("TP56" "TP-A_TPS1D5_NC_TP_" "TPS1D5" "IC" "IC") list("TP63" "TP-A_TPS1D5_NC_TP_" "TPS1D5" "IC" "IC") list("TP64" "TP-A_TPS1D5_NC_TP_" "TPS1D5" "IC" "IC") list("TP4" "TP-A_TPS1D5_NC_TP_" "TPS1D5" "IC" "IC") list("TP66" "TP-A_TPS1D5_NC_TP_" "TPS1D5" "IC" "IC") list("TP3" "TP-A_TPS1D5_NC_TP_" "TPS1D5" "IC" "IC") list("TPT14" "TP-A_TPS1D5_NC_TP_" "TPS1D5" "IC" "IC") list("M3" "MARK_0_FIDUCIAL_C40M80_NC_MARK" "FIDUCIAL_C40M80" "IC" "IC") list("M8" "MARK_0_FIDUCIAL_C40M80_NC_MARK" "FIDUCIAL_C40M80" "IC" "IC") list("M5" "MARK_0_FIDUCIAL_C40M80_NC_MARK" "FIDUCIAL_C40M80" "IC" "IC") list("M1" "MARK_0_FIDUCIAL_C40M80_NC_MARK" "FIDUCIAL_C40M80" "IC" "IC") list("M6" "MARK_0_FIDUCIAL_C40M80_NC_MARK" "FIDUCIAL_C40M80" "IC" "IC") list("M7" "MARK_0_FIDUCIAL_C40M80_NC_MARK" "FIDUCIAL_C40M80" "IC" "IC") list("M4" "MARK_0_FIDUCIAL_C40M80_NC_MARK" "FIDUCIAL_C40M80" "IC" "IC") list("M2" "MARK_0_FIDUCIAL_C40M80_NC_MARK" "FIDUCIAL_C40M80" "IC" "IC") list("F2" "FIX_GMTH90_NC_FIX" "GMTH90" "IC" "IC") list("F3" "FIX_GMTH90_NC_FIX" "GMTH90" "IC" "IC") list("F1" "FIX_GMTH90_NC_FIX" "GMTH90" "IC" "IC") list("F4" "FIX_GMTH90_NC_FIX" "GMTH90" "IC" "IC") list("Y3" "RF-SMD-2P_R1206_WAN3216F245C04_" "R1206_PC" "IC" "IC") list("RT93" "R_0_R0402_NC_0R/0402/1%_" "R0402_PC" "DISCRETE" "DISCRETE") list("RT74" "R_0_R0402_NC_0R/0402/1%_" "R0402_PC" "DISCRETE" "DISCRETE") list("TPT21" "TP-A_TPS1D0M1D2_NC_TP-A_" "TPS1D0M1D2" "IC" "IC") list("TPT24" "TP-A_TPS1D0M1D2_NC_TP-A_" "TPS1D0M1D2" "IC" "IC") list("TPT23" "TP-A_TPS1D0M1D2_NC_TP-A_" "TPS1D0M1D2" "IC" "IC") list("TPT22" "TP-A_TPS1D0M1D2_NC_TP-A_" "TPS1D0M1D2" "IC" "IC") list("TPB18" "TP-A_TPS1D0M1D2_NC_TP-A_" "TPS1D0M1D2" "IC" "IC") list("TPB22" "TP-A_TPS1D0M1D2_NC_TP-A_" "TPS1D0M1D2" "IC" "IC") list("TPB26" "TP-A_TPS1D0M1D2_NC_TP-A_" "TPS1D0M1D2" "IC" "IC") list("TPB16" "TP-A_TPS1D0M1D2_NC_TP-A_" "TPS1D0M1D2" "IC" "IC") list("TPB17" "TP-A_TPS1D0M1D2_NC_TP-A_" "TPS1D0M1D2" "IC" "IC") list("TPB15" "TP-A_TPS1D0M1D2_NC_TP-A_" "TPS1D0M1D2" "IC" "IC") list("TPB23" "TP-A_TPS1D0M1D2_NC_TP-A_" "TPS1D0M1D2" "IC" "IC") list("TPT9" "TP-A_TPS1D0M1D2_NC_TP-A_" "TPS1D0M1D2" "IC" "IC") list("TPT7" "TP-A_TPS1D0M1D2_NC_TP-A_" "TPS1D0M1D2" "IC" "IC") list("TPT20" "TP-A_TPS1D0M1D2_NC_TP-A_" "TPS1D0M1D2" "IC" "IC") list("TPT16" "TP-A_TPS1D0M1D2_NC_TP-A_" "TPS1D0M1D2" "IC" "IC") list("TPT15" "TP-A_TPS1D0M1D2_NC_TP-A_" "TPS1D0M1D2" "IC" "IC") list("TPT18" "TP-A_TPS1D0M1D2_NC_TP-A_" "TPS1D0M1D2" "IC" "IC") list("TPT28" "TP-A_TPS1D0M1D2_NC_TP-A_" "TPS1D0M1D2" "IC" "IC") list("TPT39" "TP-A_TPS1D0M1D2_NC_TP-A_" "TPS1D0M1D2" "IC" "IC") list("TPT29" "TP-A_TPS1D0M1D2_NC_TP-A_" "TPS1D0M1D2" "IC" "IC") list("TPT36" "TP-A_TPS1D0M1D2_NC_TP-A_" "TPS1D0M1D2" "IC" "IC") list("TPT12" "TP-A_TPS1D0M1D2_NC_TP-A_" "TPS1D0M1D2" "IC" "IC") list("TPT13" "TP-A_TPS1D0M1D2_NC_TP-A_" "TPS1D0M1D2" "IC" "IC") list("TPT19" "TP-A_TPS1D0M1D2_NC_TP-A_" "TPS1D0M1D2" "IC" "IC") list("TPT17" "TP-A_TPS1D0M1D2_NC_TP-A_" "TPS1D0M1D2" "IC" "IC") list("TPT30" "TP-A_TPS1D0M1D2_NC_TP-A_" "TPS1D0M1D2" "IC" "IC") list("TPB50" "TP-A_TPS1D0M1D2_NC_TP-A_" "TPS1D0M1D2" "IC" "IC") list("TPB45" "TP-A_TPS1D0M1D2_NC_TP-A_" "TPS1D0M1D2" "IC" "IC") list("TPB53" "TP-A_TPS1D0M1D2_NC_TP-A_" "TPS1D0M1D2" "IC" "IC") list("TPB42" "TP-A_TPS1D0M1D2_NC_TP-A_" "TPS1D0M1D2" "IC" "IC") list("TPB51" "TP-A_TPS1D0M1D2_NC_TP-A_" "TPS1D0M1D2" "IC" "IC") list("TPB44" "TP-A_TPS1D0M1D2_NC_TP-A_" "TPS1D0M1D2" "IC" "IC") list("TP62" "TP-A_TPS1D0M1D2_NC_TP-A_" "TPS1D0M1D2" "IC" "IC") list("TP57" "TP-A_TPS1D0M1D2_NC_TP-A_" "TPS1D0M1D2" "IC" "IC") list("TP102" "TP-A_TPS1D0M1D2_NC_TP-A_" "TPS1D0M1D2" "IC" "IC") list("TPT32" "TP-A_TPS1D0M1D2_NC_TP-A_" "TPS1D0M1D2" "IC" "IC") list("TPB61" "TP-A_TPS1D0M1D2_NC_TP-A_" "TPS1D0M1D2" "IC" "IC") list("TPB60" "TP-A_TPS1D0M1D2_NC_TP-A_" "TPS1D0M1D2" "IC" "IC") list("TPB59" "TP-A_TPS1D0M1D2_NC_TP-A_" "TPS1D0M1D2" "IC" "IC") list("TPB24" "TP-A_TPS1D0M1D2_NC_TP-A_" "TPS1D0M1D2" "IC" "IC") list("TPB20" "TP-A_TPS1D0M1D2_NC_TP-A_" "TPS1D0M1D2" "IC" "IC") list("TPB19" "TP-A_TPS1D0M1D2_NC_TP-A_" "TPS1D0M1D2" "IC" "IC") list("TP95" "TP-A_TPS1D0M1D2_NC_TP-A_" "TPS1D0M1D2" "IC" "IC") list("TP53" "TP-A_TPS1D0M1D2_NC_TP-A_" "TPS1D0M1D2" "IC" "IC") list("TP113" "TP-A_TPS1D0M1D2_NC_TP-A_" "TPS1D0M1D2" "IC" "IC") list("TPB80" "TP-A_TPS1D0M1D2_NC_TP-A_" "TPS1D0M1D2" "IC" "IC") list("TPB79" "TP-A_TPS1D0M1D2_NC_TP-A_" "TPS1D0M1D2" "IC" "IC") list("TPB78" "TP-A_TPS1D0M1D2_NC_TP-A_" "TPS1D0M1D2" "IC" "IC") list("TPB77" "TP-A_TPS1D0M1D2_NC_TP-A_" "TPS1D0M1D2" "IC" "IC") list("TPB76" "TP-A_TPS1D0M1D2_NC_TP-A_" "TPS1D0M1D2" "IC" "IC") list("TPB75" "TP-A_TPS1D0M1D2_NC_TP-A_" "TPS1D0M1D2" "IC" "IC") list("TPB74" "TP-A_TPS1D0M1D2_NC_TP-A_" "TPS1D0M1D2" "IC" "IC") list("TPB73" "TP-A_TPS1D0M1D2_NC_TP-A_" "TPS1D0M1D2" "IC" "IC") list("TPB72" "TP-A_TPS1D0M1D2_NC_TP-A_" "TPS1D0M1D2" "IC" "IC") list("TPB71" "TP-A_TPS1D0M1D2_NC_TP-A_" "TPS1D0M1D2" "IC" "IC") list("TPB69" "TP-A_TPS1D0M1D2_NC_TP-A_" "TPS1D0M1D2" "IC" "IC") list("TPB68" "TP-A_TPS1D0M1D2_NC_TP-A_" "TPS1D0M1D2" "IC" "IC") list("TPB67" "TP-A_TPS1D0M1D2_NC_TP-A_" "TPS1D0M1D2" "IC" "IC") list("TPB66" "TP-A_TPS1D0M1D2_NC_TP-A_" "TPS1D0M1D2" "IC" "IC") list("TPB65" "TP-A_TPS1D0M1D2_NC_TP-A_" "TPS1D0M1D2" "IC" "IC") list("TPB64" "TP-A_TPS1D0M1D2_NC_TP-A_" "TPS1D0M1D2" "IC" "IC") list("TPB63" "TP-A_TPS1D0M1D2_NC_TP-A_" "TPS1D0M1D2" "IC" "IC") list("TPB62" "TP-A_TPS1D0M1D2_NC_TP-A_" "TPS1D0M1D2" "IC" "IC") list("TPB58" "TP-A_TPS1D0M1D2_NC_TP-A_" "TPS1D0M1D2" "IC" "IC") list("TP37" "TP-A_TPS1D0M1D2_NC_TP-A_" "TPS1D0M1D2" "IC" "IC") list("TP35" "TP-A_TPS1D0M1D2_NC_TP-A_" "TPS1D0M1D2" "IC" "IC") list("TP34" "TP-A_TPS1D0M1D2_NC_TP-A_" "TPS1D0M1D2" "IC" "IC") list("TPB10" "TP-A_TPS1D0M1D2_NC_TP-A_" "TPS1D0M1D2" "IC" "IC") list("TP22" "TP-A_TEST_C40_SMD_NC_TP-A_" "TEST_C40_SMD" "IC" "IC") list("TP21" "TP-A_TEST_C40_SMD_NC_TP-A_" "TEST_C40_SMD" "IC" "IC") list("TP25" "TP-A_TEST_C40_SMD_NC_TP-A_" "TEST_C40_SMD" "IC" "IC") list("TP26" "TP-A_TEST_C40_SMD_NC_TP-A_" "TEST_C40_SMD" "IC" "IC") list("TP24" "TP-A_TEST_C40_SMD_NC_TP-A_" "TEST_C40_SMD" "IC" "IC") list("TP23" "TP-A_TEST_C40_SMD_NC_TP-A_" "TEST_C40_SMD" "IC" "IC") list("C34" "CAP_C0402_NC/C0402_000200000035" "C0402_PC" "IC" "IC") list("C80" "CAP_C0402_NC/C0402_000200000035" "C0402_PC" "IC" "IC") list("C197" "CAP_C0402_10NF/0402/25V/10%_" "C0402_PC" "IC" "IC") list("RT28" "R_R0402_100R/0402/1%_" "R0402_PC" "IC" "IC") list("RT25" "R_R0402_100R/0402/1%_" "R0402_PC" "IC" "IC") list("CT23" "CAP_C0603_10UF/0603/25V/20%_" "C0603_PC" "IC" "IC") list("RT4" "R_R0402_5M/0402/1%_" "R0402_PC" "IC" "IC") list("RB3" "R_R0402_22K/0402/1%_" "R0402_PC" "DISCRETE" "DISCRETE") list("QT4" "N-MOS-SOT89_SOT-89-3L_AP4438" "SOT-89-3L" "IC" "IC") list("D4" "SS24_DO-214AA_SMB_P6SMB24CA_" "DO-214AA_SMB" "IC" "IC") list("U33" "RS0101_SOT23-6_RS1T45XH6_" "SOT23-6" "IC" "IC") list("U9" "RS0101_SOT23-6_RS1T45XH6_" "SOT23-6" "IC" "IC") list("U10" "RS0101_SOT23-6_RS1T45XH6_" "SOT23-6" "IC" "IC") list("R256" "R_R0402_CVB1005E121T_" "R0402_PC" "IC" "IC") list("LT2" "CD42-2R2UH_L7268_GDIM0640-1R5M" "L7268_PC" "IC" "IC") list("RT29" "R_R0402_2.2K/0402/1%_" "R0402_PC" "IC" "IC") list("RT31" "R_R0402_2.2K/0402/1%_" "R0402_PC" "IC" "IC") list("RT23" "R_R0402_2.2K/0402/1%_" "R0402_PC" "IC" "IC") list("RT19" "R_R0402_2.2K/0402/1%_" "R0402_PC" "IC" "IC") list("R1" "R_R0402_NC_1K/0402/1%_" "R0402_PC" "DISCRETE" "DISCRETE") list("LT1" "CD42-2R2UH_L7268_GDIM0624-2R2S1" "L7268_PC" "IC" "IC") list("DB1" "SS24_SOD-123FL_B5818W_" "SOD-123FL" "IC" "IC") list("C6" "CAP_C0402_51PF/0402/50V/5%_" "C0402_PC" "IC" "IC") list("C349" "CAP_C0402_51PF/0402/50V/5%_" "C0402_PC" "IC" "IC") list("TPB7" "TP-A_TPS-2D5_NC_TP-A_" "TPS-2D5" "IC" "IC") list("TPB8" "TP-A_TPS-2D5_NC_TP-A_" "TPS-2D5" "IC" "IC") list("TP49" "TP-A_TPS_0D8_0D9_NC_TP-A_" "TPS_0D8_0D9" "IC" "IC") list("TP46" "TP-A_TPS_0D8_0D9_NC_TP-A_" "TPS_0D8_0D9" "IC" "IC") list("TP116" "TP-A_TPS_0D8_0D9_NC_TP-A_" "TPS_0D8_0D9" "IC" "IC") list("TP122" "TP-A_TPS_0D8_0D9_NC_TP-A_" "TPS_0D8_0D9" "IC" "IC") list("TP112" "TP-A_TPS_0D8_0D9_NC_TP-A_" "TPS_0D8_0D9" "IC" "IC") list("TP105" "TP-A_TPS_0D8_0D9_NC_TP-A_" "TPS_0D8_0D9" "IC" "IC") list("TP101" "TP-A_TPS_0D8_0D9_NC_TP-A_" "TPS_0D8_0D9" "IC" "IC") list("C162" "CAP_C0603_10UF/0603/6.3V/20%_" "C0603_PC" "IC" "IC") list("C163" "CAP_C0603_10UF/0603/6.3V/20%_" "C0603_PC" "IC" "IC") list("U30" "JW5250A_SOT23-5_JW5262NMSOTA#TR" "SOT23-5" "IC" "IC") list("Q3" "N-MOS2_SOT-523_NC_2SK3019" "SOT-523" "IC" "IC") list("Q4" "N-MOS2_SOT-523_NC_2SK3019" "SOT-523" "IC" "IC") list("Q26" "N-MOS2_SOT-523_NC_2SK3019" "SOT-523" "IC" "IC") list("RT67" "R_R0402_NC_1.3K/0402/1%_" "R0402_PC" "DISCRETE" "DISCRETE") list("C375" "CAP_C0402_NC_1NF/0402/16V/10%_" "C0402_PC" "IC" "IC") list("U38" "RS0101_SOT23-6_NC_RS1T45XH6_" "SOT23-6" "IC" "IC") list("U37" "RS0101_SOT23-6_NC_RS1T45XH6_" "SOT23-6" "IC" "IC") list("R9" "R_R0402_NC_100R/0402/1%_" "R0402_PC" "IC" "IC") list("R8" "R_R0402_NC_100R/0402/1%_" "R0402_PC" "IC" "IC") list("R24" "R_R0402_NC_100R/0402/1%_" "R0402_PC" "IC" "IC") list("R23" "R_R0402_NC_100R/0402/1%_" "R0402_PC" "IC" "IC") list("C113" "CAP_C0402_27PF/0402/50V/5%_" "C0402_PC" "IC" "IC") list("C107" "CAP_C0402_27PF/0402/50V/5%_" "C0402_PC" "IC" "IC") list("R293" "R_R0603_0R/0603/1%_000000000041" "R0603_PC" "IC" "IC") list("R291" "R_R0603_0R/0603/1%_000000000041" "R0603_PC" "IC" "IC") list("R102" "R_R0603_1K/0603/1%_000000000041" "R0603_PC" "IC" "IC") list("R7" "R_R0402_40.2K/0402/1%_" "R0402_PC" "DISCRETE" "DISCRETE") list("L16" "L_L3015_SWPA3015S2R2NT_" "L3015_PC" "IC" "IC") list("DB9" "SS24_SOD-323F_ESD56151W04-2/TR_" "SOD-323" "IC" "IC") list("DB8" "SS24_SOD-323F_ESD56151W04-2/TR_" "SOD-323" "IC" "IC") list("DB7" "SS24_SOD-323F_ESD56151W04-2/TR_" "SOD-323" "IC" "IC") list("DB6" "SS24_SOD-323F_ESD56151W04-2/TR_" "SOD-323" "IC" "IC") list("DB11" "SS24_SOD-323F_ESD56151W04-2/TR_" "SOD-323" "IC" "IC") list("DB10" "SS24_SOD-323F_ESD56151W04-2/TR_" "SOD-323" "IC" "IC") list("TPB57" "TP-A_TPS_SH20_16OBSL_NC_TP-A_" "TPS_SH20_16OBSL" "IC" "IC") list("TPB46" "TP-A_TPS_SH20_16OBSL_NC_TP-A_" "TPS_SH20_16OBSL" "IC" "IC") list("TPB38" "TP-A_TPS_SH20_16OBSL_NC_TP-A_" "TPS_SH20_16OBSL" "IC" "IC") list("U39" "BL7122_SOP-8_BL7122AH_" "SOP-8" "IC" "IC") list("XT2" "SW-PB4_SW-PB4_3X3X1D5_TSK-03151" "SW-PB4_3X3X1D5" "IC" "IC") list("XT1" "SW-PB4_SW-PB4_3X3X1D5_TSK-03151" "SW-PB4_3X3X1D5" "IC" "IC") list("YT3" "OSCILLATOR_SMD_OSC_SMD_3225_S_1" "OSC_SMD_3225" "IC" "IC") list("YT2" "OSCILLATOR_SMD_OSC_SMD_3225_S_1" "OSC_SMD_3225" "IC" "IC") list("YT1" "OSCILLATOR_SMD_OSC_SMD_3225_S_1" "OSC_SMD_3225" "IC" "IC") list("X3" "OSCILLATOR_SMD_OSC_SMD_3225_S_1" "OSC_SMD_3225" "IC" "IC") list("X2" "OSC_KYOCERA_32K768_3225_1V8_5V0" "OSC_SMD_3225" "IC" "IC") list("Y1" "OSCILLATOR_SMD_OSC_SMD_3225_SX3" "OSC_SMD_3225" "IC" "IC") list("X1" "OSCILLATOR_SMD_OSC_SMD_3225_SX3" "OSC_SMD_3225" "IC" "IC") list("UT1" "HC32F460PETB-LQFP100_LQFP-100_H" "LQFP-100" "IC" "IC") list("UB2" "XM25QH32BHIG_SOP-8L-208MIL_NC_X" "SOP-8L-208MIL" "IC" "IC") list("UB1" "SY8121ABC_SOT23-6L_JW5352HMSOTB" "SOT23-6L" "IC" "IC") list("U8" "PSMN1R8-40YLC_SON-8P-5X6MM_WSD3" "SON-8P-5X6MM" "IC" "IC") list("U35" "RTL8811CU1_RTL8811_13X12D5_BL-M" "RTL8811_13X12D5" "IC" "IC") list("U32" "74LVC1G125_SOT23-5_74LVC1G126-G" "SOT23-5" "IC" "IC") list("U26" "IC_KEROS_CK22AT_SOT-23-6_NC_CK2" "SOT-23-6" "IC" "IC") list("U34" "SPX3819M5-L-1-8/TR_SOT23-5_ME63" "SOT23-5" "IC" "IC") list("U31" "SPX3819M5-L-1-8/TR_SOT23-5_ME63" "SOT23-5" "IC" "IC") list("U29" "SPX3819M5-L-1-8/TR_SOT23-5_ME63" "SOT23-5" "IC" "IC") list("U28" "SPX3819M5-L-1-8/TR_SOT23-5_ME63" "SOT23-5" "IC" "IC") list("U25" "SPX3819M5-L-1-8/TR_SOT23-5_ME63" "SOT23-5" "IC" "IC") list("U23" "74AXP4T245-TSSOP_TSSOP16_RS4T24" "TSSOP16" "IC" "IC") list("U22" "TH1520_QFN80P900X900X80-81_TH15" "QFN80P900X900X80-81" "IC" "IC") list("U18" "IL005_1_QFN08P_2X2X0_5_NC_ASC00" "QFN08P_2X2X0_5" "IC" "IC") list("U16" "IL005_1_QFN08P_2X2X0_5_NC_ASC00" "QFN08P_2X2X0_5" "IC" "IC") list("U14" "IC_HYNIX_H9HCNNN8KUMLHR_NMI_FBG" "FBGA200_80P_150X100X90" "IC" "IC") list("U13" "X3_LPDDR4_V5_REF_200331A_X2A_(S" "X2A" "IC" "IC") list("U7" "JW5255_QFN10-3X3_2X5P_JW5255ADF" "QFN10-3X3_2X5P" "IC" "IC") list("U6" "JW5255_QFN10-3X3_2X5P_JW5255ADF" "QFN10-3X3_2X5P" "IC" "IC") list("U4" "JW5255_QFN10-3X3_2X5P_JW5255ADF" "QFN10-3X3_2X5P" "IC" "IC") list("U3" "JW5255_QFN10-3X3_2X5P_JW5255ADF" "QFN10-3X3_2X5P" "IC" "IC") list("U2" "JW5255_QFN10-3X3_2X5P_JW5255ADF" "QFN10-3X3_2X5P" "IC" "IC") list("U19" "JW5255_QFN10-3X3_2X5P_JW5255ADF" "QFN10-3X3_2X5P" "IC" "IC") list("U15" "JW5255_QFN10-3X3_2X5P_JW5255ADF" "QFN10-3X3_2X5P" "IC" "IC") list("U11" "JW5255_QFN10-3X3_2X5P_JW5255ADF" "QFN10-3X3_2X5P" "IC" "IC") list("U1" "JW5372_SOT23-6_JW5056TSOTB#TRPB" "SOT23-6" "IC" "IC") list("TP99" "TESTPOINT_CIRCLE_0R4MM_TPS-0D4_" "TPS-0D4" "IC" "IC") list("TP98" "TESTPOINT_CIRCLE_0R4MM_TPS-0D4_" "TPS-0D4" "IC" "IC") list("TP92" "TESTPOINT_CIRCLE_0R4MM_TPS-0D4_" "TPS-0D4" "IC" "IC") list("TP91" "TESTPOINT_CIRCLE_0R4MM_TPS-0D4_" "TPS-0D4" "IC" "IC") list("TP90" "TESTPOINT_CIRCLE_0R4MM_TPS-0D4_" "TPS-0D4" "IC" "IC") list("TP88" "TESTPOINT_CIRCLE_0R4MM_TPS-0D4_" "TPS-0D4" "IC" "IC") list("TP86" "TESTPOINT_CIRCLE_0R4MM_TPS-0D4_" "TPS-0D4" "IC" "IC") list("TP85" "TESTPOINT_CIRCLE_0R4MM_TPS-0D4_" "TPS-0D4" "IC" "IC") list("TP83" "TESTPOINT_CIRCLE_0R4MM_TPS-0D4_" "TPS-0D4" "IC" "IC") list("TP82" "TESTPOINT_CIRCLE_0R4MM_TPS-0D4_" "TPS-0D4" "IC" "IC") list("TP80" "TESTPOINT_CIRCLE_0R4MM_TPS-0D4_" "TPS-0D4" "IC" "IC") list("TP79" "TESTPOINT_CIRCLE_0R4MM_TPS-0D4_" "TPS-0D4" "IC" "IC") list("TP78" "TESTPOINT_CIRCLE_0R4MM_TPS-0D4_" "TPS-0D4" "IC" "IC") list("TP77" "TESTPOINT_CIRCLE_0R4MM_TPS-0D4_" "TPS-0D4" "IC" "IC") list("TP76" "TESTPOINT_CIRCLE_0R4MM_TPS-0D4_" "TPS-0D4" "IC" "IC") list("TP75" "TESTPOINT_CIRCLE_0R4MM_TPS-0D4_" "TPS-0D4" "IC" "IC") list("TP72" "TESTPOINT_CIRCLE_0R4MM_TPS-0D4_" "TPS-0D4" "IC" "IC") list("TP71" "TESTPOINT_CIRCLE_0R4MM_TPS-0D4_" "TPS-0D4" "IC" "IC") list("TP70" "TESTPOINT_CIRCLE_0R4MM_TPS-0D4_" "TPS-0D4" "IC" "IC") list("TP69" "TESTPOINT_CIRCLE_0R4MM_TPS-0D4_" "TPS-0D4" "IC" "IC") list("TP68" "TESTPOINT_CIRCLE_0R4MM_TPS-0D4_" "TPS-0D4" "IC" "IC") list("TP97" "TESTPOINT_CIRCLE_0R5MM_TPS-0D_1" "TPS-0D4" "IC" "IC") list("TP96" "TESTPOINT_CIRCLE_0R5MM_TPS-0D_1" "TPS-0D4" "IC" "IC") list("TP45" "TESTPOINT_CIRCLE_0R5MM_TPS-0D_1" "TPS-0D4" "IC" "IC") list("TP43" "TESTPOINT_CIRCLE_0R5MM_TPS-0D_1" "TPS-0D4" "IC" "IC") list("TP42" "TESTPOINT_CIRCLE_0R5MM_TPS-0D_1" "TPS-0D4" "IC" "IC") list("TP41" "TESTPOINT_CIRCLE_0R5MM_TPS-0D_1" "TPS-0D4" "IC" "IC") list("TP94" "TESTPOINT_CIRCLE_0R5MM_TESTPAD_" "TESTPAD_S1_00" "IC" "IC") list("TP29" "TESTPOINT_CIRCLE_0R5MM_TESTPAD_" "TESTPAD_S1_00" "IC" "IC") list("TP28" "TESTPOINT_CIRCLE_0R5MM_TESTPAD_" "TESTPAD_S1_00" "IC" "IC") list("TP136" "TESTPOINT_CIRCLE_0R5MM_TPS-0D4_" "TPS-0D4" "IC" "IC") list("TP55" "TESTPOINT_CIRCLE_0R4MM_TEST_C40" "TEST_C40_SMD" "IC" "IC") list("TP135" "TESTPOINT_CIRCLE_0R4MM_TEST_C40" "TEST_C40_SMD" "IC" "IC") list("TP134" "TESTPOINT_CIRCLE_0R4MM_TEST_C40" "TEST_C40_SMD" "IC" "IC") list("TP133" "TESTPOINT_CIRCLE_0R4MM_TEST_C40" "TEST_C40_SMD" "IC" "IC") list("TP132" "TESTPOINT_CIRCLE_0R4MM_TEST_C40" "TEST_C40_SMD" "IC" "IC") list("TP126" "TESTPOINT_CIRCLE_0R4MM_TEST_C40" "TEST_C40_SMD" "IC" "IC") list("TP125" "TESTPOINT_CIRCLE_0R4MM_TEST_C40" "TEST_C40_SMD" "IC" "IC") list("TP111" "TESTPOINT_CIRCLE_0R4MM_TEST_C40" "TEST_C40_SMD" "IC" "IC") list("RT79" "R_R0402_36.5K/0402/1%_000000000" "R0402_PC" "IC" "IC") list("RT96" "R_0_R0402_NC_1M/0402/1%_0000000" "R0402_PC" "IC" "IC") list("RT73" "R_0_R0402_NC_1M/0402/1%_0000000" "R0402_PC" "IC" "IC") list("RT95" "R_0_R0402_0R/0402/1%_0000000000" "R0402_PC" "IC" "IC") list("RT72" "R_0_R0402_0R/0402/1%_0000000000" "R0402_PC" "IC" "IC") list("RT84" "R_0_R0402_0R/0402/1%_0000000000" "R0402_PC" "IC" "IC") list("RT11" "R_R0402_510R/0402/1%_0000000000" "R0402_PC" "IC" "IC") list("RP4" "RP-4P_RP1206-4P0603_0R/0603X4/1" "RP1206-4P0603" "IC" "IC") list("RP3" "RP-4P_RP1206-4P0603_0R/0603X4/1" "RP1206-4P0603" "IC" "IC") list("RP2" "RP-4P_RP1206-4P0603_0R/0603X4/1" "RP1206-4P0603" "IC" "IC") list("RP1" "RP-4P_RP1206-4P0603_0R/0603X4/1" "RP1206-4P0603" "IC" "IC") list("RP5" "RP-4P_RP1206-4P0603_0R/0603X4/1" "RP1206-4P0603" "IC" "IC") list("RB50" "R_0_R0402_NC_5.1K/0402/1%_00000" "R0402_PC" "IC" "IC") list("RB44" "R_0_R0402_NC_5.1K/0402/1%_00000" "R0402_PC" "IC" "IC") list("RB23" "R_0_R0402_NC_5.1K/0402/1%_00000" "R0402_PC" "IC" "IC") list("RB22" "R_0_R0402_NC_5.1K/0402/1%_00000" "R0402_PC" "IC" "IC") list("R41" "R_R0402_22.1K/0402/1%_000000000" "R0402_PC" "IC" "IC") list("R61" "R_R0402_200K/0402/1%_0000000000" "R0402_PC" "IC" "IC") list("R34" "R_R0402_200K/0402/1%_0000000000" "R0402_PC" "IC" "IC") list("R33" "R_R0402_240K/0402/1%_0000000000" "R0402_PC" "IC" "IC") list("R90" "R_R0402_270K/0402/1%_0000000000" "R0402_PC" "IC" "IC") list("R28" "R_R0402_270K/0402/1%_0000000000" "R0402_PC" "IC" "IC") list("R260" "R_R0402_NC_100K/0402/1%_0000000" "R0402_PC" "IC" "IC") list("R252" "R_R0402_309K/0402/1%_0000000000" "R0402_PC" "IC" "IC") list("R231" "R_R0402_309K/0402/1%_0000000000" "R0402_PC" "IC" "IC") list("R228" "R_R0402_56K/0402/1%_00000000004" "R0402_PC" "IC" "IC") list("R199" "R_R0402_22R/0402/1%_00000000004" "R0402_PC" "DISCRETE" "DISCRETE") list("R213" "R_R0402_100R/0402/1%_0000000000" "R0402_PC" "IC" "IC") list("R198" "R_R0402_100R/0402/1%_0000000000" "R0402_PC" "IC" "IC") list("R227" "R_R0402_47K/0402/1%_00000000004" "R0402_PC" "IC" "IC") list("R212" "R_R0402_47K/0402/1%_00000000004" "R0402_PC" "IC" "IC") list("R200" "R_R0402_47K/0402/1%_00000000004" "R0402_PC" "IC" "IC") list("R197" "R_R0402_47K/0402/1%_00000000004" "R0402_PC" "IC" "IC") list("R196" "R_R0402_47K/0402/1%_00000000004" "R0402_PC" "IC" "IC") list("R194" "R_R0402_47K/0402/1%_00000000004" "R0402_PC" "IC" "IC") list("R193" "R_R0402_47K/0402/1%_00000000004" "R0402_PC" "IC" "IC") list("R192" "R_R0402_47K/0402/1%_00000000004" "R0402_PC" "IC" "IC") list("R191" "R_R0402_47K/0402/1%_00000000004" "R0402_PC" "IC" "IC") list("R189" "R_R0402_47K/0402/1%_00000000004" "R0402_PC" "IC" "IC") list("R188" "R_R0402_47K/0402/1%_00000000004" "R0402_PC" "IC" "IC") list("R170" "R_R0402_47K/0402/1%_00000000004" "R0402_PC" "IC" "IC") list("R168" "R_R0402_47K/0402/1%_00000000004" "R0402_PC" "IC" "IC") list("R296" "R_R0402_47K/0402/1%_00000000004" "R0402_PC" "IC" "IC") list("R167" "R_R0402_59K/0402/1%_00000000004" "R0402_PC" "IC" "IC") list("R98" "R_R0402_4.7R/0402/1%_0000000000" "R0402_PC" "IC" "IC") list("R88" "R_R0402_4.7R/0402/1%_0000000000" "R0402_PC" "IC" "IC") list("R70" "R_R0402_4.7R/0402/1%_0000000000" "R0402_PC" "IC" "IC") list("R45" "R_R0402_4.7R/0402/1%_0000000000" "R0402_PC" "IC" "IC") list("R44" "R_R0402_4.7R/0402/1%_0000000000" "R0402_PC" "IC" "IC") list("R43" "R_R0402_4.7R/0402/1%_0000000000" "R0402_PC" "IC" "IC") list("R26" "R_R0402_4.7R/0402/1%_0000000000" "R0402_PC" "IC" "IC") list("R132" "R_R0402_4.7R/0402/1%_0000000000" "R0402_PC" "IC" "IC") list("R94" "R_R0402_10R/0402/1%_00000000004" "R0402_PC" "IC" "IC") list("R84" "R_R0402_10R/0402/1%_00000000004" "R0402_PC" "IC" "IC") list("R60" "R_R0402_10R/0402/1%_00000000004" "R0402_PC" "IC" "IC") list("R46" "R_R0402_10R/0402/1%_00000000004" "R0402_PC" "IC" "IC") list("R36" "R_R0402_10R/0402/1%_00000000004" "R0402_PC" "IC" "IC") list("R35" "R_R0402_10R/0402/1%_00000000004" "R0402_PC" "IC" "IC") list("R32" "R_R0402_10R/0402/1%_00000000004" "R0402_PC" "IC" "IC") list("R128" "R_R0402_10R/0402/1%_00000000004" "R0402_PC" "IC" "IC") list("R130" "R_R0402_71.5K/0402/1%_000000000" "R0402_PC" "IC" "IC") list("R119" "R_R0402_71.5K/0402/1%_000000000" "R0402_PC" "IC" "IC") list("RB26" "R_R0402_4.7K/0402/1%_0000000000" "R0402_PC" "IC" "IC") list("R235" "R_R0402_4.7K/0402/1%_0000000000" "R0402_PC" "IC" "IC") list("R229" "R_R0402_4.7K/0402/1%_0000000000" "R0402_PC" "IC" "IC") list("R184" "R_R0402_4.7K/0402/1%_0000000000" "R0402_PC" "IC" "IC") list("R179" "R_R0402_4.7K/0402/1%_0000000000" "R0402_PC" "IC" "IC") list("R166" "R_R0402_4.7K/0402/1%_0000000000" "R0402_PC" "IC" "IC") list("R164" "R_R0402_4.7K/0402/1%_0000000000" "R0402_PC" "IC" "IC") list("R160" "R_R0402_4.7K/0402/1%_0000000000" "R0402_PC" "IC" "IC") list("R142" "R_R0402_4.7K/0402/1%_0000000000" "R0402_PC" "IC" "IC") list("R138" "R_R0402_4.7K/0402/1%_0000000000" "R0402_PC" "IC" "IC") list("R125" "R_R0402_4.7K/0402/1%_0000000000" "R0402_PC" "IC" "IC") list("R118" "R_R0402_4.7K/0402/1%_0000000000" "R0402_PC" "IC" "IC") list("R82" "R_R0402_300K/0402/1%_0000000000" "R0402_PC" "IC" "IC") list("R56" "R_R0402_300K/0402/1%_0000000000" "R0402_PC" "IC" "IC") list("R114" "R_R0402_300K/0402/1%_0000000000" "R0402_PC" "IC" "IC") list("RT99" "R_R0402_10K/0402/1%_00000000004" "R0402_PC" "IC" "IC") list("RT88" "R_R0402_10K/0402/1%_00000000004" "R0402_PC" "IC" "IC") list("R99" "R_R0402_10K/0402/1%_00000000004" "R0402_PC" "IC" "IC") list("R93" "R_R0402_10K/0402/1%_00000000004" "R0402_PC" "IC" "IC") list("R85" "R_R0402_10K/0402/1%_00000000004" "R0402_PC" "IC" "IC") list("R81" "R_R0402_10K/0402/1%_00000000004" "R0402_PC" "IC" "IC") list("R75" "R_R0402_10K/0402/1%_00000000004" "R0402_PC" "IC" "IC") list("R65" "R_R0402_10K/0402/1%_00000000004" "R0402_PC" "IC" "IC") list("R64" "R_R0402_10K/0402/1%_00000000004" "R0402_PC" "IC" "IC") list("R59" "R_R0402_10K/0402/1%_00000000004" "R0402_PC" "IC" "IC") list("R40" "R_R0402_10K/0402/1%_00000000004" "R0402_PC" "IC" "IC") list("R38" "R_R0402_10K/0402/1%_00000000004" "R0402_PC" "IC" "IC") list("R37" "R_R0402_10K/0402/1%_00000000004" "R0402_PC" "IC" "IC") list("R29" "R_R0402_10K/0402/1%_00000000004" "R0402_PC" "IC" "IC") list("R289" "R_R0402_10K/0402/1%_00000000004" "R0402_PC" "IC" "IC") list("R288" "R_R0402_10K/0402/1%_00000000004" "R0402_PC" "IC" "IC") list("R240" "R_R0402_10K/0402/1%_00000000004" "R0402_PC" "IC" "IC") list("R237" "R_R0402_10K/0402/1%_00000000004" "R0402_PC" "IC" "IC") list("R210" "R_R0402_10K/0402/1%_00000000004" "R0402_PC" "IC" "IC") list("R190" "R_R0402_10K/0402/1%_00000000004" "R0402_PC" "IC" "IC") list("R181" "R_R0402_10K/0402/1%_00000000004" "R0402_PC" "IC" "IC") list("R162" "R_R0402_10K/0402/1%_00000000004" "R0402_PC" "IC" "IC") list("R159" "R_R0402_10K/0402/1%_00000000004" "R0402_PC" "IC" "IC") list("R156" "R_R0402_10K/0402/1%_00000000004" "R0402_PC" "IC" "IC") list("R152" "R_R0402_10K/0402/1%_00000000004" "R0402_PC" "IC" "IC") list("R148" "R_R0402_10K/0402/1%_00000000004" "R0402_PC" "IC" "IC") list("R126" "R_R0402_10K/0402/1%_00000000004" "R0402_PC" "IC" "IC") list("R111" "R_R0402_10K/0402/1%_00000000004" "R0402_PC" "IC" "IC") list("R302" "R_R0402_10K/0402/1%_00000000004" "R0402_PC" "IC" "IC") list("R298" "R_R0402_10K/0402/1%_00000000004" "R0402_PC" "IC" "IC") list("RT83" "R_R0402_10K/0402/1%_00000000004" "R0402_PC" "IC" "IC") list("R92" "R_R0402_NC_10K/0402/1%_00000000" "R0402_PC" "IC" "IC") list("R80" "R_R0402_NC_10K/0402/1%_00000000" "R0402_PC" "IC" "IC") list("R58" "R_R0402_NC_10K/0402/1%_00000000" "R0402_PC" "IC" "IC") list("R31" "R_R0402_NC_10K/0402/1%_00000000" "R0402_PC" "IC" "IC") list("R207" "R_R0402_NC_10K/0402/1%_00000000" "R0402_PC" "IC" "IC") list("R110" "R_R0402_NC_10K/0402/1%_00000000" "R0402_PC" "IC" "IC") list("R290" "R_R0402_NC_10K/0402/1%_00000000" "R0402_PC" "IC" "IC") list("R292" "R_R0402_NC_10K/0402/1%_00000000" "R0402_PC" "IC" "IC") list("R303" "R_R0402_NC_10K/0402/1%_00000000" "R0402_PC" "IC" "IC") list("R301" "R_R0402_NC_10K/0402/1%_00000000" "R0402_PC" "IC" "IC") list("R91" "R_R0402_100K/0402/1%_0000000000" "R0402_PC" "IC" "IC") list("R89" "R_R0402_100K/0402/1%_0000000000" "R0402_PC" "IC" "IC") list("R83" "R_R0402_100K/0402/1%_0000000000" "R0402_PC" "IC" "IC") list("R79" "R_R0402_100K/0402/1%_0000000000" "R0402_PC" "IC" "IC") list("R63" "R_R0402_100K/0402/1%_0000000000" "R0402_PC" "IC" "IC") list("R62" "R_R0402_100K/0402/1%_0000000000" "R0402_PC" "IC" "IC") list("R57" "R_R0402_100K/0402/1%_0000000000" "R0402_PC" "IC" "IC") list("R55" "R_R0402_100K/0402/1%_0000000000" "R0402_PC" "IC" "IC") list("R42" "R_R0402_100K/0402/1%_0000000000" "R0402_PC" "IC" "IC") list("R39" "R_R0402_100K/0402/1%_0000000000" "R0402_PC" "IC" "IC") list("R30" "R_R0402_100K/0402/1%_0000000000" "R0402_PC" "IC" "IC") list("R27" "R_R0402_100K/0402/1%_0000000000" "R0402_PC" "IC" "IC") list("R263" "R_R0402_100K/0402/1%_0000000000" "R0402_PC" "IC" "IC") list("R259" "R_R0402_100K/0402/1%_0000000000" "R0402_PC" "IC" "IC") list("R236" "R_R0402_100K/0402/1%_0000000000" "R0402_PC" "IC" "IC") list("R234" "R_R0402_100K/0402/1%_0000000000" "R0402_PC" "IC" "IC") list("R202" "R_R0402_100K/0402/1%_0000000000" "R0402_PC" "IC" "IC") list("R201" "R_R0402_100K/0402/1%_0000000000" "R0402_PC" "IC" "IC") list("R169" "R_R0402_100K/0402/1%_0000000000" "R0402_PC" "IC" "IC") list("R149" "R_R0402_100K/0402/1%_0000000000" "R0402_PC" "IC" "IC") list("R145" "R_R0402_100K/0402/1%_0000000000" "R0402_PC" "IC" "IC") list("R143" "R_R0402_100K/0402/1%_0000000000" "R0402_PC" "IC" "IC") list("R135" "R_R0402_100K/0402/1%_0000000000" "R0402_PC" "IC" "IC") list("R134" "R_R0402_100K/0402/1%_0000000000" "R0402_PC" "IC" "IC") list("R113" "R_R0402_100K/0402/1%_0000000000" "R0402_PC" "IC" "IC") list("R112" "R_R0402_100K/0402/1%_0000000000" "R0402_PC" "IC" "IC") list("R109" "R_R0402_100K/0402/1%_0000000000" "R0402_PC" "IC" "IC") list("RT82" "R_R0402_33R/0402/1%_00000000004" "R0402_PC" "IC" "IC") list("RT77" "R_R0402_33R/0402/1%_00000000004" "R0402_PC" "IC" "IC") list("R107" "R_R0402_33R/0402/1%_00000000004" "R0402_PC" "IC" "IC") list("R139" "R_R0402_33R/0402/1%_00000000004" "R0402_PC" "IC" "IC") list("QB1" "CJA100P03_SON-8P-5X6MM_CJAC100P" "SON-8P-5X6MM" "IC" "IC") list("LT4" "FR_0505_CMF2G-505024-4P_CMF2G50" "CMF2G-505024-4P" "IC" "IC") list("LT3" "FR_0505_CMF2G-505024-4P_NC_CMF2" "CMF2G-505024-4P" "IC" "IC") list("L3" "CD32-3R3UH_L545730_NC_MHCI05030" "L545730" "DISCRETE" "DISCRETE") list("JT5" "A1501WR-S-4P_XH-4P-2D54-H_XH25L" "XH-4P-2D54-H" "IC" "IC") list("JT10" "FPC0520HX-10P_FPC0520HX-10P_FPC" "FPC0520HX-10P" "IC" "IC") list("JT1" "XH-5P-2D5-W_HY-5P-2D0-H_PH20LB-" "HY-5P-2D0-H" "IC" "IC") list("J9" "DF36A-25S-0.4V_DF36A-25S-04V_DF" "DF36A-25S-04V" "IC" "IC") list("J6" "FPC0520HX-30P_FPC0520HX-30P_FPC" "FPC0520HX-30P" "IC" "IC") list("JT8" "A1002WR-S-3P_SH-03P-1D0-H_A1002" "SH-03P-1D0-H" "IC" "IC") list("JB2" "A1002WR-S-3P_SH-03P-1D0-H_A1002" "SH-03P-1D0-H" "IC" "IC") list("J5" "A1002WR-S-3P_SH-03P-1D0-H_A1002" "SH-03P-1D0-H" "IC" "IC") list("J2" "BTB-LB222-G30S-W0R01_LB230-G30S" "LB230-G30S-BOR" "IC" "IC") list("J1" "A1002WR-S-4P_SH-04P-1D0-H_A1002" "SH-04P-1D0-H" "IC" "IC") list("FIX6" "FIX-9P_FIX_2D2_4D0-9P_NC_FIX_2D" "FIX_2D2_4D0-9P" "IC" "IC") list("FIX5" "FIX-9P_FIX_2D2_4D0-9P_NC_FIX_2D" "FIX_2D2_4D0-9P" "IC" "IC") list("FIX4" "FIX-9P_FIX_2D2_4D0-9P_NC_FIX_2D" "FIX_2D2_4D0-9P" "IC" "IC") list("FIX3" "FIX-9P_FIX_2D2_4D0-9P_NC_FIX_2D" "FIX_2D2_4D0-9P" "IC" "IC") list("FIX2" "FIX-9P_FIX_2D2_4D0-9P_NC_FIX_2D" "FIX_2D2_4D0-9P" "IC" "IC") list("FIX1" "FIX-9P_FIX_2D2_4D0-9P_NC_FIX_2D" "FIX_2D2_4D0-9P" "IC" "IC") list("ET3" "C_ELEC_E8012SMT_RVT470UF16V67RV" "E8012SMT" "IC" "IC") list("ET2" "C_ELEC_E8012SMT_RVT470UF16V67RV" "E8012SMT" "IC" "IC") list("ET1" "C_ELEC_E8012SMT_RVT470UF16V67RV" "E8012SMT" "IC" "IC") list("D2" "PS2701_PS2701-1_NC_CYPS2701-1(L" "PS2701-1" "IC" "IC") list("D1" "PS2701_PS2701-1_NC_CYPS2701-1(L" "PS2701-1" "IC" "IC") list("CT9" "CAP_C0402_10PF/0402/50V/5%_0002" "C0402_PC" "IC" "IC") list("CT6" "CAP_C0402_10PF/0402/50V/5%_0002" "C0402_PC" "IC" "IC") list("CT35" "CAP_C0603_1UF/0603/25V/10%_0002" "C0603_PC" "IC" "IC") list("CT32" "CAP_C0603_1UF/0603/25V/10%_0002" "C0603_PC" "IC" "IC") list("CT28" "CAP_C0402_2.2UF/0402/6.3V/10%_1" "C0402_PC" "IC" "IC") list("CT153" "CAP_C0402_100PF/0402/50V/5%_000" "C0402_PC" "IC" "IC") list("CT152" "CAP_C0402_100PF/0402/50V/5%_000" "C0402_PC" "IC" "IC") list("CT151" "CAP_C0402_100PF/0402/50V/5%_000" "C0402_PC" "IC" "IC") list("CT150" "CAP_C0402_100PF/0402/50V/5%_000" "C0402_PC" "IC" "IC") list("CT149" "CAP_C0402_100PF/0402/50V/5%_000" "C0402_PC" "IC" "IC") list("CT148" "CAP_C0402_100PF/0402/50V/5%_000" "C0402_PC" "IC" "IC") list("CT145" "CAP_0_C0402_NC_33PF/0402/50V/5%" "C0402_PC" "IC" "IC") list("CT144" "CAP_0_C0402_NC_33PF/0402/50V/5%" "C0402_PC" "IC" "IC") list("CT143" "CAP_0_C0402_NC_33PF/0402/50V/5%" "C0402_PC" "IC" "IC") list("CT142" "CAP_0_C0402_NC_33PF/0402/50V/5%" "C0402_PC" "IC" "IC") list("CT141" "CAP_0_C0402_NC_33PF/0402/50V/5%" "C0402_PC" "IC" "IC") list("CT140" "CAP_0_C0402_NC_33PF/0402/50V/5%" "C0402_PC" "IC" "IC") list("CT139" "CAP_0_C0402_NC_33PF/0402/50V/5%" "C0402_PC" "IC" "IC") list("CT90" "CAP_0_C0402_10PF/0402/50V/5%_00" "C0402_PC" "IC" "IC") list("CT128" "CAP_0_C0402_10PF/0402/50V/5%_00" "C0402_PC" "IC" "IC") list("CT89" "CAP_0_C0402_1PF/0402/50V/10%_00" "C0402_PC" "IC" "IC") list("CT88" "CAP_0_C0402_1PF/0402/50V/10%_00" "C0402_PC" "IC" "IC") list("CT127" "CAP_0_C0402_1PF/0402/50V/10%_00" "C0402_PC" "IC" "IC") list("CT126" "CAP_0_C0402_1PF/0402/50V/10%_00" "C0402_PC" "IC" "IC") list("CT92" "CAP_0_C0402_2.2UF/0402/6.3V/10%" "C0402_PC" "IC" "IC") list("CT122" "CAP_0_C0402_2.2UF/0402/6.3V/10%" "C0402_PC" "IC" "IC") list("CT97" "CAP_0_C0402_100NF/0402/25V/10%_" "C0402_PC" "IC" "IC") list("CT95" "CAP_0_C0402_100NF/0402/25V/10%_" "C0402_PC" "IC" "IC") list("CT93" "CAP_0_C0402_100NF/0402/25V/10%_" "C0402_PC" "IC" "IC") list("CT87" "CAP_0_C0402_100NF/0402/25V/10%_" "C0402_PC" "IC" "IC") list("CT85" "CAP_0_C0402_100NF/0402/25V/10%_" "C0402_PC" "IC" "IC") list("CT84" "CAP_0_C0402_100NF/0402/25V/10%_" "C0402_PC" "IC" "IC") list("CT136" "CAP_0_C0402_100NF/0402/25V/10%_" "C0402_PC" "IC" "IC") list("CT135" "CAP_0_C0402_100NF/0402/25V/10%_" "C0402_PC" "IC" "IC") list("CT130" "CAP_0_C0402_100NF/0402/25V/10%_" "C0402_PC" "IC" "IC") list("CT121" "CAP_0_C0402_100NF/0402/25V/10%_" "C0402_PC" "IC" "IC") list("CT115" "CAP_0_C0402_100NF/0402/25V/10%_" "C0402_PC" "IC" "IC") list("CT111" "CAP_0_C0402_100NF/0402/25V/10%_" "C0402_PC" "IC" "IC") list("CT91" "CAP_0_C0402_1UF/0402/6.3V/10%_0" "C0402_PC" "IC" "IC") list("CT123" "CAP_0_C0402_1UF/0402/6.3V/10%_0" "C0402_PC" "IC" "IC") list("CT112" "CAP_0_C0402_1UF/0402/6.3V/10%_0" "C0402_PC" "IC" "IC") list("CT110" "CAP_0_C0402_1UF/0402/6.3V/10%_0" "C0402_PC" "IC" "IC") list("CT98" "CAP_0_C0603_10UF/0603/6.3V/10%_" "C0603_PC" "IC" "IC") list("CT96" "CAP_0_C0603_10UF/0603/6.3V/10%_" "C0603_PC" "IC" "IC") list("CT94" "CAP_0_C0603_10UF/0603/6.3V/10%_" "C0603_PC" "IC" "IC") list("CT86" "CAP_0_C0603_10UF/0603/6.3V/10%_" "C0603_PC" "IC" "IC") list("CT82" "CAP_0_C0603_10UF/0603/6.3V/10%_" "C0603_PC" "IC" "IC") list("CT137" "CAP_0_C0603_10UF/0603/6.3V/10%_" "C0603_PC" "IC" "IC") list("CT133" "CAP_0_C0603_10UF/0603/6.3V/10%_" "C0603_PC" "IC" "IC") list("CT116" "CAP_0_C0603_10UF/0603/6.3V/10%_" "C0603_PC" "IC" "IC") list("CT113" "CAP_0_C0603_10UF/0603/6.3V/10%_" "C0603_PC" "IC" "IC") list("CT108" "CAP_0_C0603_10UF/0603/6.3V/10%_" "C0603_PC" "IC" "IC") list("CT18" "CAP_C0603_10UF/0603/25V/20%_000" "C0603_PC" "IC" "IC") list("CT107" "CAP_C0603_10UF/0603/25V/20%_000" "C0603_PC" "IC" "IC") list("CT105" "CAP_C0603_10UF/0603/25V/20%_000" "C0603_PC" "IC" "IC") list("CT109" "CAP_C0603_10UF/0603/25V/20%_000" "C0603_PC" "IC" "IC") list("CT102" "CAP_C0402_NC_100NF/0402/25V/10%" "C0402_PC" "IC" "IC") list("CT101" "CAP_C0402_NC_100NF/0402/25V/10%" "C0402_PC" "IC" "IC") list("CT106" "CAP_C0805_22UF/0805/25V/20%_000" "C0805_PC" "IC" "IC") list("CB14" "CAP_C0805_22UF/0805/25V/20%_000" "C0805_PC" "IC" "IC") list("CB13" "CAP_C0805_22UF/0805/25V/20%_000" "C0805_PC" "IC" "IC") list("CB28" "CAP_C0805_22UF/0805/25V/20%_000" "C0805_PC" "IC" "IC") list("CB27" "CAP_C0805_22UF/0805/25V/20%_000" "C0805_PC" "IC" "IC") list("CB11" "CAP_C0603_10UF/0603/16V/20%_000" "C0603_PC" "IC" "IC") list("C378" "CAP_C0603_10UF/0603/16V/20%_000" "C0603_PC" "IC" "IC") list("C373" "CAP_C0402_NC_8.2PF/0402/16V/10%" "C0402_PC" "IC" "IC") list("C37" "CAP_C0402_NC_1UF/0402/6.3V/10%_" "C0402_PC" "IC" "IC") list("CT147" "CAP_C0402_100NF/0402/25V/10%__2" "C0402_PC" "IC" "IC") list("CT118" "CAP_C0402_100NF/0402/25V/10%__2" "C0402_PC" "IC" "IC") list("C359" "CAP_C0402_100NF/0402/25V/10%__2" "C0402_PC" "IC" "IC") list("C354" "CAP_C0805_22UF/0805/10V/20%_000" "C0805_PC" "IC" "IC") list("C343" "CAP_C0805_22UF/0805/10V/20%_000" "C0805_PC" "IC" "IC") list("CT37" "CAP_C0402_100NF/0402/25V/10%__1" "C0402_PC" "IC" "IC") list("C365" "CAP_C0402_100NF/0402/25V/10%__1" "C0402_PC" "IC" "IC") list("C356" "CAP_C0402_100NF/0402/25V/10%__1" "C0402_PC" "IC" "IC") list("C348" "CAP_C0402_100NF/0402/25V/10%__1" "C0402_PC" "IC" "IC") list("C340" "CAP_C0402_100NF/0402/25V/10%__1" "C0402_PC" "IC" "IC") list("C332" "CAP_C0201_10NF/0201/6.3V/10%_00" "C0201_PC" "IC" "IC") list("C347" "CAP_C0201_100NF/0201/10V/10%_00" "C0201_PC" "IC" "IC") list("C345" "CAP_C0201_100NF/0201/10V/10%_00" "C0201_PC" "IC" "IC") list("C339" "CAP_C0201_100NF/0201/10V/10%_00" "C0201_PC" "IC" "IC") list("C320" "CAP_C0201_100NF/0201/10V/10%_00" "C0201_PC" "IC" "IC") list("C318" "CAP_C0201_100NF/0201/10V/10%_00" "C0201_PC" "IC" "IC") list("C316" "CAP_C0201_100NF/0201/10V/10%_00" "C0201_PC" "IC" "IC") list("CT36" "CAP_C0402_1UF/0402/6.3V/10%_0_1" "C0402_PC" "IC" "IC") list("CT34" "CAP_C0402_1UF/0402/6.3V/10%_0_1" "C0402_PC" "IC" "IC") list("CT33" "CAP_C0402_1UF/0402/6.3V/10%_0_1" "C0402_PC" "IC" "IC") list("C344" "CAP_C0402_1UF/0402/6.3V/10%_0_1" "C0402_PC" "IC" "IC") list("C271" "CAP_C0402_1UF/0402/6.3V/10%_0_1" "C0402_PC" "IC" "IC") list("C73" "CAP_C0402_10NF/0402/6.3V/10%_00" "C0402_PC" "IC" "IC") list("C341" "CAP_C0402_10NF/0402/6.3V/10%_00" "C0402_PC" "IC" "IC") list("C323" "CAP_C0402_10NF/0402/6.3V/10%_00" "C0402_PC" "IC" "IC") list("C321" "CAP_C0402_10NF/0402/6.3V/10%_00" "C0402_PC" "IC" "IC") list("C314" "CAP_C0402_10NF/0402/6.3V/10%_00" "C0402_PC" "IC" "IC") list("C245" "CAP_C0402_10NF/0402/6.3V/10%_00" "C0402_PC" "IC" "IC") list("C244" "CAP_C0402_10NF/0402/6.3V/10%_00" "C0402_PC" "IC" "IC") list("C240" "CAP_C0402_10NF/0402/6.3V/10%_00" "C0402_PC" "IC" "IC") list("C238" "CAP_C0402_10NF/0402/6.3V/10%_00" "C0402_PC" "IC" "IC") list("C335" "CAP_C0402_4.7UF/0402/10V/10%__1" "C0402_PC" "IC" "IC") list("C333" "CAP_C0402_4.7UF/0402/10V/10%__1" "C0402_PC" "IC" "IC") list("C329" "CAP_C0402_4.7UF/0402/10V/10%__1" "C0402_PC" "IC" "IC") list("C322" "CAP_C0402_4.7UF/0402/10V/10%__1" "C0402_PC" "IC" "IC") list("C310" "CAP_C0402_4.7UF/0402/10V/10%__1" "C0402_PC" "IC" "IC") list("C283" "CAP_C0402_4.7UF/0402/10V/10%__1" "C0402_PC" "IC" "IC") list("C281" "CAP_C0402_4.7UF/0402/10V/10%__1" "C0402_PC" "IC" "IC") list("C274" "CAP_C0402_4.7UF/0402/10V/10%__1" "C0402_PC" "IC" "IC") list("C249" "CAP_C0402_4.7UF/0402/10V/10%__1" "C0402_PC" "IC" "IC") list("C232" "CAP_C0402_4.7UF/0402/10V/10%__1" "C0402_PC" "IC" "IC") list("C222" "CAP_C0402_4.7UF/0402/10V/10%__1" "C0402_PC" "IC" "IC") list("C218" "CAP_C0402_4.7UF/0402/10V/10%__1" "C0402_PC" "IC" "IC") list("C215" "CAP_C0402_4.7UF/0402/10V/10%__1" "C0402_PC" "IC" "IC") list("C94" "CAP_C0402_1.5NF/0402/6.3V/10%_0" "C0402_PC" "IC" "IC") list("C342" "CAP_C0402_1.5NF/0402/6.3V/10%_0" "C0402_PC" "IC" "IC") list("C202" "CAP_C0402_1.5NF/0402/6.3V/10%_0" "C0402_PC" "IC" "IC") list("C191" "CAP_C0402_2.2UF/0402/6.3V/10%_0" "C0402_PC" "IC" "IC") list("C189" "CAP_C0402_2.2UF/0402/6.3V/10%_0" "C0402_PC" "IC" "IC") list("C98" "CAP_C0805_22UF/0805/6.3V/20%_00" "C0805_PC" "IC" "IC") list("C97" "CAP_C0805_22UF/0805/6.3V/20%_00" "C0805_PC" "IC" "IC") list("C84" "CAP_C0805_22UF/0805/6.3V/20%_00" "C0805_PC" "IC" "IC") list("C83" "CAP_C0805_22UF/0805/6.3V/20%_00" "C0805_PC" "IC" "IC") list("C75" "CAP_C0805_22UF/0805/6.3V/20%_00" "C0805_PC" "IC" "IC") list("C74" "CAP_C0805_22UF/0805/6.3V/20%_00" "C0805_PC" "IC" "IC") list("C46" "CAP_C0805_22UF/0805/6.3V/20%_00" "C0805_PC" "IC" "IC") list("C45" "CAP_C0805_22UF/0805/6.3V/20%_00" "C0805_PC" "IC" "IC") list("C44" "CAP_C0805_22UF/0805/6.3V/20%_00" "C0805_PC" "IC" "IC") list("C351" "CAP_C0805_22UF/0805/6.3V/20%_00" "C0805_PC" "IC" "IC") list("C35" "CAP_C0805_22UF/0805/6.3V/20%_00" "C0805_PC" "IC" "IC") list("C29" "CAP_C0805_22UF/0805/6.3V/20%_00" "C0805_PC" "IC" "IC") list("C23" "CAP_C0805_22UF/0805/6.3V/20%_00" "C0805_PC" "IC" "IC") list("C22" "CAP_C0805_22UF/0805/6.3V/20%_00" "C0805_PC" "IC" "IC") list("C213" "CAP_C0805_22UF/0805/6.3V/20%_00" "C0805_PC" "IC" "IC") list("C21" "CAP_C0805_22UF/0805/6.3V/20%_00" "C0805_PC" "IC" "IC") list("C186" "CAP_C0805_22UF/0805/6.3V/20%_00" "C0805_PC" "IC" "IC") list("C173" "CAP_C0805_22UF/0805/6.3V/20%_00" "C0805_PC" "IC" "IC") list("C14" "CAP_C0402_4.7UF/0402/10V/10%_00" "C0402_PC" "IC" "IC") list("C99" "CAP_C0402_2.2NF/0402/16V/10%_00" "C0402_PC" "IC" "IC") list("C86" "CAP_C0402_2.2NF/0402/16V/10%_00" "C0402_PC" "IC" "IC") list("C71" "CAP_C0402_2.2NF/0402/16V/10%_00" "C0402_PC" "IC" "IC") list("C56" "CAP_C0402_2.2NF/0402/16V/10%_00" "C0402_PC" "IC" "IC") list("C47" "CAP_C0402_2.2NF/0402/16V/10%_00" "C0402_PC" "IC" "IC") list("C43" "CAP_C0402_2.2NF/0402/16V/10%_00" "C0402_PC" "IC" "IC") list("C18" "CAP_C0402_2.2NF/0402/16V/10%_00" "C0402_PC" "IC" "IC") list("C134" "CAP_C0402_2.2NF/0402/16V/10%_00" "C0402_PC" "IC" "IC") list("CT99" "CAP_C0805_22UF/0805/16V/20%_000" "C0805_PC" "IC" "IC") list("CT8" "CAP_C0805_22UF/0805/16V/20%_000" "C0805_PC" "IC" "IC") list("CT4" "CAP_C0805_22UF/0805/16V/20%_000" "C0805_PC" "IC" "IC") list("CT38" "CAP_C0805_22UF/0805/16V/20%_000" "C0805_PC" "IC" "IC") list("CT3" "CAP_C0805_22UF/0805/16V/20%_000" "C0805_PC" "IC" "IC") list("CT155" "CAP_C0805_22UF/0805/16V/20%_000" "C0805_PC" "IC" "IC") list("CT154" "CAP_C0805_22UF/0805/16V/20%_000" "C0805_PC" "IC" "IC") list("CT146" "CAP_C0805_22UF/0805/16V/20%_000" "C0805_PC" "IC" "IC") list("CT100" "CAP_C0805_22UF/0805/16V/20%_000" "C0805_PC" "IC" "IC") list("CB22" "CAP_C0805_22UF/0805/16V/20%_000" "C0805_PC" "IC" "IC") list("CB19" "CAP_C0805_22UF/0805/16V/20%_000" "C0805_PC" "IC" "IC") list("CB18" "CAP_C0805_22UF/0805/16V/20%_000" "C0805_PC" "IC" "IC") list("CB17" "CAP_C0805_22UF/0805/16V/20%_000" "C0805_PC" "IC" "IC") list("CB15" "CAP_C0805_22UF/0805/16V/20%_000" "C0805_PC" "IC" "IC") list("CB12" "CAP_C0805_22UF/0805/16V/20%_000" "C0805_PC" "IC" "IC") list("CB10" "CAP_C0805_22UF/0805/16V/20%_000" "C0805_PC" "IC" "IC") list("C5" "CAP_C0805_22UF/0805/16V/20%_000" "C0805_PC" "IC" "IC") list("C41" "CAP_C0805_22UF/0805/16V/20%_000" "C0805_PC" "IC" "IC") list("C369" "CAP_C0805_22UF/0805/16V/20%_000" "C0805_PC" "IC" "IC") list("C30" "CAP_C0805_22UF/0805/16V/20%_000" "C0805_PC" "IC" "IC") list("C133" "CAP_C0805_22UF/0805/16V/20%_000" "C0805_PC" "IC" "IC") list("C132" "CAP_C0805_22UF/0805/16V/20%_000" "C0805_PC" "IC" "IC") list("CT49" "CAP_C0805_22UF/0805/16V/20%_000" "C0805_PC" "IC" "IC") list("CT48" "CAP_C0805_22UF/0805/16V/20%_000" "C0805_PC" "IC" "IC") list("CT47" "CAP_C0805_22UF/0805/16V/20%_000" "C0805_PC" "IC" "IC") list("CT43" "CAP_C0805_22UF/0805/16V/20%_000" "C0805_PC" "IC" "IC") list("CT53" "CAP_C0805_22UF/0805/16V/20%_000" "C0805_PC" "IC" "IC") list("CT52" "CAP_C0805_22UF/0805/16V/20%_000" "C0805_PC" "IC" "IC") list("C95" "CAP_C0402_100NF/0402/25V/10%_00" "C0402_PC" "IC" "IC") list("C82" "CAP_C0402_100NF/0402/25V/10%_00" "C0402_PC" "IC" "IC") list("C66" "CAP_C0402_100NF/0402/25V/10%_00" "C0402_PC" "IC" "IC") list("C33" "CAP_C0402_100NF/0402/25V/10%_00" "C0402_PC" "IC" "IC") list("C27" "CAP_C0402_100NF/0402/25V/10%_00" "C0402_PC" "IC" "IC") list("C194" "CAP_C0402_100NF/0402/25V/10%_00" "C0402_PC" "IC" "IC") list("C188" "CAP_C0402_100NF/0402/25V/10%_00" "C0402_PC" "IC" "IC") list("C184" "CAP_C0402_100NF/0402/25V/10%_00" "C0402_PC" "IC" "IC") list("C183" "CAP_C0402_100NF/0402/25V/10%_00" "C0402_PC" "IC" "IC") list("C13" "CAP_C0402_100NF/0402/25V/10%_00" "C0402_PC" "IC" "IC") list("C50" "CAP_C0402_100NF/0402/16V/10%_00" "C0402_PC" "IC" "IC") list("C15" "CAP_C0402_100NF/0402/16V/10%_00" "C0402_PC" "IC" "IC") list("C125" "CAP_C0402_100NF/0402/16V/10%_00" "C0402_PC" "IC" "IC") list("C93" "CAP_C0402_1UF/0402/6.3V/10%_000" "C0402_PC" "IC" "IC") list("C81" "CAP_C0402_1UF/0402/6.3V/10%_000" "C0402_PC" "IC" "IC") list("C60" "CAP_C0402_1UF/0402/6.3V/10%_000" "C0402_PC" "IC" "IC") list("C54" "CAP_C0402_1UF/0402/6.3V/10%_000" "C0402_PC" "IC" "IC") list("C346" "CAP_C0402_1UF/0402/6.3V/10%_000" "C0402_PC" "IC" "IC") list("C31" "CAP_C0402_1UF/0402/6.3V/10%_000" "C0402_PC" "IC" "IC") list("C28" "CAP_C0402_1UF/0402/6.3V/10%_000" "C0402_PC" "IC" "IC") list("C17" "CAP_C0402_1UF/0402/6.3V/10%_000" "C0402_PC" "IC" "IC") list("C120" "CAP_C0402_1UF/0402/6.3V/10%_000" "C0402_PC" "IC" "IC") list("C91" "CAP_C0402_NC_100NF/0402/16V/10%" "C0402_PC" "IC" "IC") list("C78" "CAP_C0402_NC_100NF/0402/16V/10%" "C0402_PC" "IC" "IC") list("C65" "CAP_C0402_NC_100NF/0402/16V/10%" "C0402_PC" "IC" "IC") list("C53" "CAP_C0402_NC_100NF/0402/16V/10%" "C0402_PC" "IC" "IC") list("C32" "CAP_C0402_NC_100NF/0402/16V/10%" "C0402_PC" "IC" "IC") list("C20" "CAP_C0402_NC_100NF/0402/16V/10%" "C0402_PC" "IC" "IC") list("C109" "CAP_C0402_NC_100NF/0402/16V/10%" "C0402_PC" "IC" "IC") list("CT31" "CAP_C0603_10UF/0603/6.3V/10%_00" "C0603_PC" "IC" "IC") list("CT21" "CAP_C0603_10UF/0603/6.3V/10%_00" "C0603_PC" "IC" "IC") list("CT12" "CAP_C0603_10UF/0603/6.3V/10%_00" "C0603_PC" "IC" "IC") list("C106" "CAP_C0603_10UF/0603/6.3V/10%_00" "C0603_PC" "IC" "IC") list("C89" "CAP_C0805_47UF/0805/6.3V/20%_00" "C0805_PC" "IC" "IC") list("C87" "CAP_C0805_47UF/0805/6.3V/20%_00" "C0805_PC" "IC" "IC") list("C79" "CAP_C0805_47UF/0805/6.3V/20%_00" "C0805_PC" "IC" "IC") list("C76" "CAP_C0805_47UF/0805/6.3V/20%_00" "C0805_PC" "IC" "IC") list("C72" "CAP_C0805_47UF/0805/6.3V/20%_00" "C0805_PC" "IC" "IC") list("C70" "CAP_C0805_47UF/0805/6.3V/20%_00" "C0805_PC" "IC" "IC") list("C62" "CAP_C0805_47UF/0805/6.3V/20%_00" "C0805_PC" "IC" "IC") list("C55" "CAP_C0805_47UF/0805/6.3V/20%_00" "C0805_PC" "IC" "IC") list("C51" "CAP_C0805_47UF/0805/6.3V/20%_00" "C0805_PC" "IC" "IC") list("C49" "CAP_C0805_47UF/0805/6.3V/20%_00" "C0805_PC" "IC" "IC") list("C389" "CAP_C0805_47UF/0805/6.3V/20%_00" "C0805_PC" "IC" "IC") list("C24" "CAP_C0805_47UF/0805/6.3V/20%_00" "C0805_PC" "IC" "IC") list("C149" "CAP_C0805_47UF/0805/6.3V/20%_00" "C0805_PC" "IC" "IC") list("C130" "CAP_C0805_47UF/0805/6.3V/20%_00" "C0805_PC" "IC" "IC") list("C112" "CAP_C0805_47UF/0805/6.3V/20%_00" "C0805_PC" "IC" "IC") list("C101" "CAP_C0805_47UF/0805/6.3V/20%_00" "C0805_PC" "IC" "IC") list("C90" "CAP_C0402_220PF/0402/50V/10%_" "C0402_PC" "IC" "IC") list("C19" "CAP_C0402_220PF/0402/50V/10%_" "C0402_PC" "IC" "IC") list("U24" "MX25V1635F_SOP-8L-208MIL_MX25L6" "SOP-8L-208MIL" "IC" "IC") list("TP74" "TP-A_TPS_0D8_0D9_NC_TP-C_" "TPS_0D8_0D9" "IC" "IC") list("TP73" "TP-A_TPS_0D8_0D9_NC_TP-C_" "TPS_0D8_0D9" "IC" "IC") list("TP33" "TP-A_TPS_0D8_0D9_NC_TP-C_" "TPS_0D8_0D9" "IC" "IC") list("TP1" "TP-A_TPS_0D8_0D9_NC_TP-C_" "TPS_0D8_0D9" "IC" "IC") list("SOLD9" "TP-A_SOLD_8D0_1D5_NC_TP-A_" "SOLD_8D0_1D5" "IC" "IC") list("SOLD8" "TP-A_SOLD_8D0_1D5_NC_TP-A_" "SOLD_8D0_1D5" "IC" "IC") list("SOLD7" "TP-A_SOLD_8D0_1D5_NC_TP-A_" "SOLD_8D0_1D5" "IC" "IC") list("SOLD6" "TP-A_SOLD_8D0_1D5_NC_TP-A_" "SOLD_8D0_1D5" "IC" "IC") list("SOLD51" "TP-A_SOLD_8D0_1D5_NC_TP-A_" "SOLD_8D0_1D5" "IC" "IC") list("SOLD50" "TP-A_SOLD_8D0_1D5_NC_TP-A_" "SOLD_8D0_1D5" "IC" "IC") list("SOLD5" "TP-A_SOLD_8D0_1D5_NC_TP-A_" "SOLD_8D0_1D5" "IC" "IC") list("SOLD49" "TP-A_SOLD_8D0_1D5_NC_TP-A_" "SOLD_8D0_1D5" "IC" "IC") list("SOLD48" "TP-A_SOLD_8D0_1D5_NC_TP-A_" "SOLD_8D0_1D5" "IC" "IC") list("SOLD47" "TP-A_SOLD_8D0_1D5_NC_TP-A_" "SOLD_8D0_1D5" "IC" "IC") list("SOLD46" "TP-A_SOLD_8D0_1D5_NC_TP-A_" "SOLD_8D0_1D5" "IC" "IC") list("SOLD45" "TP-A_SOLD_8D0_1D5_NC_TP-A_" "SOLD_8D0_1D5" "IC" "IC") list("SOLD44" "TP-A_SOLD_8D0_1D5_NC_TP-A_" "SOLD_8D0_1D5" "IC" "IC") list("SOLD43" "TP-A_SOLD_8D0_1D5_NC_TP-A_" "SOLD_8D0_1D5" "IC" "IC") list("SOLD42" "TP-A_SOLD_8D0_1D5_NC_TP-A_" "SOLD_8D0_1D5" "IC" "IC") list("SOLD41" "TP-A_SOLD_8D0_1D5_NC_TP-A_" "SOLD_8D0_1D5" "IC" "IC") list("SOLD40" "TP-A_SOLD_8D0_1D5_NC_TP-A_" "SOLD_8D0_1D5" "IC" "IC") list("SOLD4" "TP-A_SOLD_8D0_1D5_NC_TP-A_" "SOLD_8D0_1D5" "IC" "IC") list("SOLD39" "TP-A_SOLD_8D0_1D5_NC_TP-A_" "SOLD_8D0_1D5" "IC" "IC") list("SOLD38" "TP-A_SOLD_8D0_1D5_NC_TP-A_" "SOLD_8D0_1D5" "IC" "IC") list("SOLD37" "TP-A_SOLD_8D0_1D5_NC_TP-A_" "SOLD_8D0_1D5" "IC" "IC") list("SOLD36" "TP-A_SOLD_8D0_1D5_NC_TP-A_" "SOLD_8D0_1D5" "IC" "IC") list("SOLD35" "TP-A_SOLD_8D0_1D5_NC_TP-A_" "SOLD_8D0_1D5" "IC" "IC") list("SOLD34" "TP-A_SOLD_8D0_1D5_NC_TP-A_" "SOLD_8D0_1D5" "IC" "IC") list("SOLD33" "TP-A_SOLD_8D0_1D5_NC_TP-A_" "SOLD_8D0_1D5" "IC" "IC") list("SOLD32" "TP-A_SOLD_8D0_1D5_NC_TP-A_" "SOLD_8D0_1D5" "IC" "IC") list("SOLD31" "TP-A_SOLD_8D0_1D5_NC_TP-A_" "SOLD_8D0_1D5" "IC" "IC") list("SOLD30" "TP-A_SOLD_8D0_1D5_NC_TP-A_" "SOLD_8D0_1D5" "IC" "IC") list("SOLD3" "TP-A_SOLD_8D0_1D5_NC_TP-A_" "SOLD_8D0_1D5" "IC" "IC") list("SOLD29" "TP-A_SOLD_8D0_1D5_NC_TP-A_" "SOLD_8D0_1D5" "IC" "IC") list("SOLD28" "TP-A_SOLD_8D0_1D5_NC_TP-A_" "SOLD_8D0_1D5" "IC" "IC") list("SOLD27" "TP-A_SOLD_8D0_1D5_NC_TP-A_" "SOLD_8D0_1D5" "IC" "IC") list("SOLD26" "TP-A_SOLD_8D0_1D5_NC_TP-A_" "SOLD_8D0_1D5" "IC" "IC") list("SOLD25" "TP-A_SOLD_8D0_1D5_NC_TP-A_" "SOLD_8D0_1D5" "IC" "IC") list("SOLD24" "TP-A_SOLD_8D0_1D5_NC_TP-A_" "SOLD_8D0_1D5" "IC" "IC") list("SOLD23" "TP-A_SOLD_8D0_1D5_NC_TP-A_" "SOLD_8D0_1D5" "IC" "IC") list("SOLD22" "TP-A_SOLD_8D0_1D5_NC_TP-A_" "SOLD_8D0_1D5" "IC" "IC") list("SOLD21" "TP-A_SOLD_8D0_1D5_NC_TP-A_" "SOLD_8D0_1D5" "IC" "IC") list("SOLD20" "TP-A_SOLD_8D0_1D5_NC_TP-A_" "SOLD_8D0_1D5" "IC" "IC") list("SOLD2" "TP-A_SOLD_8D0_1D5_NC_TP-A_" "SOLD_8D0_1D5" "IC" "IC") list("SOLD19" "TP-A_SOLD_8D0_1D5_NC_TP-A_" "SOLD_8D0_1D5" "IC" "IC") list("SOLD18" "TP-A_SOLD_8D0_1D5_NC_TP-A_" "SOLD_8D0_1D5" "IC" "IC") list("SOLD17" "TP-A_SOLD_8D0_1D5_NC_TP-A_" "SOLD_8D0_1D5" "IC" "IC") list("SOLD16" "TP-A_SOLD_8D0_1D5_NC_TP-A_" "SOLD_8D0_1D5" "IC" "IC") list("SOLD15" "TP-A_SOLD_8D0_1D5_NC_TP-A_" "SOLD_8D0_1D5" "IC" "IC") list("SOLD14" "TP-A_SOLD_8D0_1D5_NC_TP-A_" "SOLD_8D0_1D5" "IC" "IC") list("SOLD13" "TP-A_SOLD_8D0_1D5_NC_TP-A_" "SOLD_8D0_1D5" "IC" "IC") list("SOLD12" "TP-A_SOLD_8D0_1D5_NC_TP-A_" "SOLD_8D0_1D5" "IC" "IC") list("SOLD11" "TP-A_SOLD_8D0_1D5_NC_TP-A_" "SOLD_8D0_1D5" "IC" "IC") list("SOLD10" "TP-A_SOLD_8D0_1D5_NC_TP-A_" "SOLD_8D0_1D5" "IC" "IC") list("SOLD1" "TP-A_SOLD_8D0_1D5_NC_TP-A_" "SOLD_8D0_1D5" "IC" "IC") list("TPB47" "TP-A_TPS1D0M1D2_TP-A_" "TPS1D0M1D2" "IC" "IC") list("TP9" "TP-A_TPS1D0M1D2_TP-A_" "TPS1D0M1D2" "IC" "IC") list("TP11" "TP-A_TPS1D0M1D2_TP-A_" "TPS1D0M1D2" "IC" "IC") list("TP10" "TP-A_TPS1D0M1D2_TP-A_" "TPS1D0M1D2" "IC" "IC") list("TPB82" "TP-A_TPS1D0M1D2_TP-A_" "TPS1D0M1D2" "IC" "IC") list("TPB81" "TP-A_TPS1D0M1D2_TP-A_" "TPS1D0M1D2" "IC" "IC") list("TPB70" "TP-A_TPS1D0M1D2_TP-A_" "TPS1D0M1D2" "IC" "IC") list("TPB48" "TP-A_TPS1D0M1D2_TP-A_" "TPS1D0M1D2" "IC" "IC") list("J10" "FPC0520HX-36P_FPC0520HX-36P_FPC" "FPC0520HX-36P" "IC" "IC") list("U20" "FE1_1S_B_QFN24_2_QFN24_4X4_FE1." "QFN24_4X4" "IC" "IC") list("TP59" "TP-A_TPS_0D8_0D9_TP-A_" "TPS_0D8_0D9" "IC" "IC") list("TP14" "TP-A_TPS_0D8_0D9_TP-A_" "TPS_0D8_0D9" "IC" "IC") list("TP138" "TP-A_TPS_0D8_0D9_TP-A_" "TPS_0D8_0D9" "IC" "IC") list("TP137" "TP-A_TPS_0D8_0D9_TP-A_" "TPS_0D8_0D9" "IC" "IC") list("TP104" "TP-A_TPS_0D8_0D9_TP-A_" "TPS_0D8_0D9" "IC" "IC") list("RT78" "R_R0402_49.9K/0402/1%_" "R0402_PC" "IC" "IC") list("JB1" "CON4+2_0_MH-4P-1D25-H_MX125LB-0" "MH-4P-1D25-H" "IC" "IC") list("J8" "SH-2P_MH-2P-1D25-H_MX125LB-02P" "MH-2P-1D25-H" "IC" "IC") list("J7" "SH-2P_MH-2P-1D25-H_MX125LB-02P" "MH-2P-1D25-H" "IC" "IC") list("J3" "ZH15TB-05P_ZH-05P-1D5-H_ZH15LB-" "ZH-05P-1D5-H" "IC" "IC") list("CL8" "CLIP_CLIP-MB102B_NC_ECT81800013" "CLIP-MB102B" "IC" "IC") list("CL7" "CLIP_CLIP-MB102B_NC_ECT81800013" "CLIP-MB102B" "IC" "IC") list("CL6" "CLIP_CLIP-MB102B_NC_ECT81800013" "CLIP-MB102B" "IC" "IC") list("CL5" "CLIP_CLIP-MB102B_NC_ECT81800013" "CLIP-MB102B" "IC" "IC") list("CL4" "CLIP_CLIP-MB102B_NC_ECT81800013" "CLIP-MB102B" "IC" "IC") list("CL3" "CLIP_CLIP-MB102B_NC_ECT81800013" "CLIP-MB102B" "IC" "IC") list("CL2" "CLIP_CLIP-MB102B_NC_ECT81800013" "CLIP-MB102B" "IC" "IC") list("CL18" "CLIP_CLIP-MB102B_NC_ECT81800013" "CLIP-MB102B" "IC" "IC") list("CL17" "CLIP_CLIP-MB102B_NC_ECT81800013" "CLIP-MB102B" "IC" "IC") list("CL16" "CLIP_CLIP-MB102B_NC_ECT81800013" "CLIP-MB102B" "IC" "IC") list("CL15" "CLIP_CLIP-MB102B_NC_ECT81800013" "CLIP-MB102B" "IC" "IC") list("CL13" "CLIP_CLIP-MB102B_NC_ECT81800013" "CLIP-MB102B" "IC" "IC") list("CL12" "CLIP_CLIP-MB102B_NC_ECT81800013" "CLIP-MB102B" "IC" "IC") list("CL11" "CLIP_CLIP-MB102B_NC_ECT81800013" "CLIP-MB102B" "IC" "IC") list("CL10" "CLIP_CLIP-MB102B_NC_ECT81800013" "CLIP-MB102B" "IC" "IC") list("CL1" "CLIP_CLIP-MB102B_NC_ECT81800013" "CLIP-MB102B" "IC" "IC") list("CL19" "CLIP_CLIP-MB102B_NC_ECT81800013" "CLIP-MB102B" "IC" "IC") list("U12" "MP2760_QFN30P50_500X400X80L88X2" "QFN30P50_500X400X80L88X25N" "IC" "IC") list("ET4" "C_ELEC_E-10X12X5_NC_2200UF" "E-10X12X5" "IC" "IC") list("ET5" "C_ELEC_E-10X12X5_NC_2200UF" "E-10X12X5" "IC" "IC") list("L21" "CD42-2R2UH_L0805_0R/0805/1%" "L0805_PC" "IC" "IC") list("L18" "CD42-2R2UH_L0805_0R/0805/1%" "L0805_PC" "IC" "IC") list("L17" "CD42-2R2UH_L0805_0R/0805/1%" "L0805_PC" "IC" "IC") list("FB2" "CD42-2R2UH_L0805_0R/0805/1%" "L0805_PC" "IC" "IC") list("CB26" "CAP_C0402_NC_10PF/0402/50V/5%_" "C0402_PC" "DISCRETE" "DISCRETE") list("RT36" "R_R0402_NC_5M/0402/1%_" "R0402_PC" "IC" "IC") list("R165" "R_R0402_CBG100505U471T_" "R0402_PC" "IC" "IC") list("R158" "R_R0402_CBG100505U471T_" "R0402_PC" "IC" "IC") list("R155" "R_R0402_CBG100505U471T_" "R0402_PC" "IC" "IC") list("R151" "R_R0402_CBG100505U471T_" "R0402_PC" "IC" "IC") list("UT6" "BP1048B2_LQFP-48_BP1048B1-P-RX" "LQFP-48" "IC" "IC") list("UT5" "BP1048B2_LQFP-48_BP1048B1-P-BT" "LQFP-48" "IC" "IC") list("U36" "BS812C-1_SOT23-6_BS812C-1_" "SOT23-6" "IC" "IC") list("TP115" "TP-MIN_TPS1D0M1D2_NC_TP_" "TPS1D0M1D2" "IC" "IC") list("R163" "R_R0402_82R/0402/1%_" "R0402_PC" "IC" "IC") list("R157" "R_R0402_82R/0402/1%_" "R0402_PC" "IC" "IC") list("R154" "R_R0402_82R/0402/1%_" "R0402_PC" "IC" "IC") list("R150" "R_R0402_82R/0402/1%_" "R0402_PC" "IC" "IC") list("PQ2" "P-MOS-DFN3X3-9P_DFN3X3-9-MOS_AP" "DFN3X3-9-MOS" "IC" "IC") list("DT16" "PESD_R0402_NC_ESD3BD3G0BF" "R0402_PC" "IC" "IC") list("DT57" "PESD_R0402_ESD15D100TA" "R0402_PC" "IC" "IC") list("DT48" "PESD_R0402_ESD15D100TA" "R0402_PC" "IC" "IC") list("DT47" "PESD_R0402_ESD15D100TA" "R0402_PC" "IC" "IC") list("DT46" "PESD_R0402_ESD15D100TA" "R0402_PC" "IC" "IC") list("DT45" "PESD_R0402_ESD15D100TA" "R0402_PC" "IC" "IC") list("DT44" "PESD_R0402_ESD15D100TA" "R0402_PC" "IC" "IC") list("D10" "PESD_R0402_ESD15D100TA" "R0402_PC" "IC" "IC") list("CL14" "CLIP_CLIP-MB101B_NC_ECT81800013" "CLIP-MB101B" "IC" "IC") list("CL9" "CLIP_CLIP-MB101B_NC_ECT81800013" "CLIP-MB101B" "IC" "IC") list("U27" "RTL8811CU1_1_RTL8189_14X12D5_BL" "RTL8189_14X12D5" "IC" "IC") list("D31" "PESD_R0402_NC_ESD3EL3BF" "R0402_PC" "IC" "IC") list("D30" "PESD_R0402_NC_ESD3EL3BF" "R0402_PC" "IC" "IC") list("JT4" "A1002WR-S-3P_SH-03P-1D0-W_A1002" "SH-03P-1D0-W" "IC" "IC") list("Y2" "RF-SMD-2P_1_ANT3216-3P-1_8X0_74" "ANT3216-3P-1_8X0_74" "IC" "IC") list("U5" "IC_HYNIX_H26M41208HPRI_FBGA153_" "FBGA153_50P_130X115X80" "IC" "IC") list("P4" "PIN-005_MH-3P-1D25-H_MX125TB-03" "MH-3P-1D25-H" "IC" "IC") list("CT83" "CAP_0_C0402_1.1PF/0402/50V/5%_0" "C0402_PC" "IC" "IC") list("CT81" "CAP_0_C0402_1.1PF/0402/50V/5%_0" "C0402_PC" "IC" "IC") list("CT138" "CAP_0_C0402_1.1PF/0402/50V/5%_0" "C0402_PC" "IC" "IC") list("CT134" "CAP_0_C0402_1.1PF/0402/50V/5%_0" "C0402_PC" "IC" "IC") list("R183" "R_R0402-1_0R/R0402/1%_" "R0402-1" "IC" "IC"))
  pub14CheckClassRows(rows t)
  count=0 foreach(s axlDBGetShapes(nil) when(member(car(parseString(s->layer "/")) '("ETCH" "BOUNDARY")) count=count+1)) unless(count==0 error("BatchDRC scope requires exact0 actual ETCH/BOUNDARY shapes\n"))
  pub21ExportCNS(dir "BEFORE_DRC_CNS") pub21DumpDRC(dir "BEFORE_ACTUAL_DRC_RECORDS")
  r=axlDRCUpdate(t)
  f=outfile(strcat(dir "/BATCH_DRC_ACTUAL_RESULT.txt")) fprintf(f "OFFICIAL_API=axlDRCUpdate(t)\nRETURN_ACTUAL_ERRORS=%L\n" r) close(f)
  unless(numberp(r) && r>=0 error("Batch DRC did not return an actual count\n"))
  pub21DumpDRC(dir "AFTER_ACTUAL_DRC_RECORDS") pub21ExportCNS(dir "AFTER_DRC_CNS") pub14CheckClassRows(rows t)
  d=axlDBGetDesign() axlDBRefreshId(d) unless(equal(d->drcState t) error("Native full Batch DRC did not become UP_TO_DATE\n"))
  count=0 foreach(s axlDBGetShapes(nil) when(member(car(parseString(s->layer "/")) '("ETCH" "BOUNDARY")) count=count+1)) unless(count==0 error("BatchDRC unexpectedly created actual Cu/Boundary\n"))
  unless(axlSaveDesign(?design strcat(dir "/BATCH_DRC_UPDATED.brd") ?noMru t ?noConfirm t) error("BatchDRC candidate save failed\n"))
  d=axlDBGetDesign() axlDBRefreshId(d) unless(equal(d->drcState t) error("DRC status dirtied during save\n"))
  f=outfile(strcat(dir "/BATCH_DRC_COMPLETE.txt")) fprintf(f "COMPLETE_ACTUAL_BATCH_DRC_WITH_REAL_ERROR_RECORDS_NO_RULE_WAIVERS_NO_ZERO_ERROR_ASSUMPTION\n") close(f) t))
