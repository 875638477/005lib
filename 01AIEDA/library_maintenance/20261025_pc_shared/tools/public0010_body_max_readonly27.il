load("D:/001DIY/005lib/01AIEDA/library_maintenance/20261025_pc_shared/tools/public_module_native_device_readonly_v2.il")
procedure(pub27BodyMaxReadonly(dir exportBodies)
 let((d p f before after)
  d=axlDBGetDesign() p=axlDBGetPropDictEntry("MAX_FILENAME_VALUE")
  before=axlDBGetProperties(d nil)
  f=outfile(strcat(dir "/MAX_PROPERTY_PROBE.ilist"))
  fprintf(f "ENTRY=%L\nENTRY_DETAILS=%L\nBEFORE=%L\n" p p->?? before) drain(f)
  when(exportBodies pub14WriteNativeDeviceBodies(dir))
  after=axlDBGetProperties(d nil)
  fprintf(f "AFTER=%L\n" after) close(f)
  unless(equal(before after) error("Read-only body export changed complete design properties\n"))
  f=outfile(strcat(dir "/MAX_PROPERTY_READONLY_COMPLETE.txt"))
  fprintf(f "MAX_PROPERTY_DICTIONARY_AND_COMPLETE_DESIGN_PROPERTIES_READ_ONLY\nFULL_BEFORE_AFTER_IDENTICAL\nNO_SETTER_NO_CREATE_NO_SAVE\n") close(f) t))
