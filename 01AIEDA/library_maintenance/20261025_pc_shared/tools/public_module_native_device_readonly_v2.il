; Definitions only. Collision-free actual compdef exports, no setters/save.
procedure(pub14PlainClasses(path)
 let((f d c)
  f=outfile(path) d=axlDBGetDesign()
  fprintf(f "refdes\tdevice_type\tpackage\tcomponent_class\tcompdef_class\tcompdef_device_type\n")
  foreach(c d->components fprintf(f "%L\t%L\t%L\t%L\t%L\t%L\n" c->name c->deviceType c->package c->class c->compdef->class c->compdef->deviceType))
  close(f) length(d->components)))
procedure(pub14WriteNativeDeviceBodies(dir)
 let((d c seen count result f outdir before after)
  before=pub14PlainClasses(strcat(dir "/PLAIN_NATIVE_COMPONENT_CLASSES.tsv"))
  d=axlDBGetDesign() seen=makeTable('pub14NativeDevices nil) count=0
  f=outfile(strcat(dir "/NATIVE_DEVICE_BODY_MANIFEST.tsv"))
  fprintf(f "device_type\tcomponent_class\tcompdef_class\tpackage\toutput_directory\tapi_return\n")
  foreach(c d->components unless(seen[c->deviceType]
   seen[c->deviceType]=t outdir=sprintf(nil "%s/device_%04d" dir count)
   unless(createDir(outdir) close(f) error("Fresh per-device output directory creation failed\n"))
   result=axlWriteDeviceFile(c->compdef outdir)
   fprintf(f "%L\t%L\t%L\t%L\t%L\t%L\n" c->deviceType c->class c->compdef->class c->package outdir result) drain(f)
   unless(result close(f) error("Official native device-file export failed\n"))
   count=count+1))
  close(f) after=pub14PlainClasses(strcat(dir "/AFTER_NATIVE_EXPORT_COMPONENT_CLASSES.tsv"))
  unless(before==after error("Read-only native component count changed\n"))
  f=outfile(strcat(dir "/NATIVE_DEVICE_BODIES_COMPLETE.txt"))
  fprintf(f "COMPLETE_READONLY_NATIVE_COMPONENT_DEFINITION_DEVICE_BODIES_V2\nDEVICES=%d\nCOMPONENTS_BEFORE=%d\nCOMPONENTS_AFTER=%d\nCLASS_SETTERS=0\nEXPLICIT_CONTEXT_LOADS=0\nSAVE_CALLS=0\n" count before after) close(f) t))
