; Read-only actual source routing/owner versus old/new REGULAR pad polygons.
; Detached source polygons survive a ROOT TOP-LEVEL open, never a nested open.
load("D:/001DIY/005lib/01AIEDA/library_maintenance/20261025_pc_shared/public0010_nil_route_stub_bundle13_v1/public0010_nil_route_stub_repair_v1.il")
procedure(pc25Step(message)
 fprintf(pc25StepPort "%s\n" message) drain(pc25StepPort))
procedure(pc25Poly(f p)
 let((first)
  fprintf(f "{\"area\":%L,\"bbox\":[[%L,%L],[%L,%L]],\"outer\":[" p->area caar(p->bBox) cadar(p->bBox) caadr(p->bBox) cadadr(p->bBox)) first=t
  foreach(v p->vertices unless(first fprintf(f ",")) first=nil fprintf(f "[%L,%L,%L]" caar(v) cadar(v) if(numberp(cadr(v)) then cadr(v) else 0.0)))
  fprintf(f "],\"holes\":[") first=t
  foreach(h p->holes unless(first fprintf(f ",")) first=nil pc25Poly(f h)) fprintf(f "]}")))
procedure(pc25WritePolys(key role ps)
 let((first)
  ; BBox uses explicit JSON brackets, not native list notation.
  fprintf(pc25PolyPort "{\"key\":%d,\"role\":%L,\"polys\":[" key role) first=t
  foreach(p ps unless(first fprintf(pc25PolyPort ",")) first=nil pc25Poly(pc25PolyPort p)) fprintf(pc25PolyPort "]}\n") drain(pc25PolyPort)))
procedure(pc25Summary(ps)
 let((area) area=0.0 foreach(p ps area=area+p->area) list(length(ps) area foreach(mapcar p ps p->bBox))))
procedure(pc25Copy(ps)
 let((r)
  ps=remove(nil ps) unless(ps error("SOURCE25 empty actual source polygon\n"))
  r=axlPolyOffset(ps '(0.0 0.0) t) when(axlPolyErrorGet() error("SOURCE25 detached clone native error\n")) r=remove(nil r)
  unless(r && null(pc13RingOp(ps r 'ANDNOT)) && null(pc13RingOp(r ps 'ANDNOT)) error("SOURCE25 detached copy is not exact\n")) r))
procedure(pc25OwnedWalk(o owner)
 let((attrs)
  when(o && !member(owner pc25Owned[o])
   pc25Owned[o]=cons(owner pc25Owned[o]) attrs=o->?
   when(member('children attrs) foreach(x o->children pc25OwnedWalk(x owner)))
   when(member('segments attrs) foreach(x o->segments pc25OwnedWalk(x owner))))))
procedure(pc25MakePinOwners()
 pc25PinOwners=makeTable('pc25PinOwners nil)
 foreach(s axlDBGetDesign()->symbols foreach(p s->pins pc25PinOwners[p]=pub403Identity(s))))
procedure(pc25PinId(p)
 list(pc25PinOwners[p] p->number p->net->name p->xy p->name pc13Props(p)))
procedure(pc25OwnerChain(o)
 let((chain seen attrs next)
  chain=nil seen=nil
  while(o && !member(o seen) && length(seen)<12
   seen=cons(o seen) attrs=o->?
   chain=cons(list(o o->objType pc13Props(o) pc25Owned[o] o->??) chain)
   next=nil when(member('parent attrs) next=o->parent) o=next)
  reverse(chain)))
procedure(pc25PinRelation(ps net layer f key phase)
 let((pads ownPads candidates p pp hit outside own)
  pads=nil ownPads=nil candidates=nil
  foreach(item pc13CuIndexRows
   when(equal(nth(4 item) "pin") && exists(poly ps pc13BoxesMeet(nth(3 item) poly->bBox))
    p=car(item) pp=pc13IndexedCuPolys(item layer)
    when(pp
     hit=pc13RingOp(ps pp 'AND)
     when(hit
      own=equal(p->net->name net) outside=pc13RingOp(ps pp 'ANDNOT)
      candidates=cons(pc25PinId(p) candidates)
      fprintf(f "%L\n" list(key phase pc25PinId(p) own pc25Summary(hit) pc25Summary(outside) p->??)) drain(f)
      pc25WritePolys(key strcat(phase "_INTERSECTING_PAD") pp)
      pads=append(pads pp) when(own ownPads=append(ownPads pp))))))
  list(ownPads candidates)))
procedure(pub0010Source25Prepare(dir)
 let((rows f ownf key objects ps row relation inside own objectsCount)
  sstatus(fullPrecision t) pub403ReadUnits()
  pub403FullTypedGate(strcat(pub403Bundle "/SOURCE_FULL2698_WITH_NONLOGICAL_IDENTITIES.ilist"))
  pub403StateGate(strcat(pub403Bundle "/SOURCE_CONTROL_EXPECTED_ALL593_TEXT_PROPS.ilist"))
  pc25SourceDRC=axlDBControl('drcEnable) pc25SourceFill=axlDBControl('dynamicFillMode)
  pc25StepPort=outfile(strcat(dir "/STEP.txt")) pc25Step("SOURCE_BEGIN")
  pub0010CollectRouteObjects() pub0010BuildCuIndex() pc25MakePinOwners()
  pc25OriginalVias=pub0010ViasSnapshot(strcat(dir "/SOURCE_ALL1739_TYPED_VIAS.ilist"))
  pc25Owned=makeTable('pc25Owned nil)
  foreach(s axlDBGetDesign()->symbols foreach(o s->children pc25OwnedWalk(o pub403Identity(s))))
  rows=pub403Rows("D:/001DIY/005lib/01AIEDA/library_maintenance/20261025_pc_shared/public0010_source25_owner_probe_bundle13_v2/SOURCE25_ACTUAL_UNCOVERED_STROKES.ilist") unless(length(rows)==25 error("SOURCE25 exact source count differs\n"))
  f=outfile(strcat(dir "/SOURCE25_ACTUAL_OWNER_CHAIN.ilist")) ownf=outfile(strcat(dir "/SOURCE25_OLD_PAD_RELATIONS.ilist"))
  pc25PolyPort=outfile(strcat(dir "/SOURCE25_ACTUAL_POLYGONS.jsonl"))
  pc25Frozen=nil key=0
  foreach(row rows
   key=key+1 objects=pub0010ActualLines[pub0010RouteGeomKey(car(row) nth(2 row) nth(3 row) nth(4 row))]
   objects=setof(o objects equal(o->net->name nth(1 row)))
   unless(objects error("SOURCE25 frozen native source line missing %L\n" row))
   ps=nil own=nil
   foreach(o objects
    ps=append(ps axlPolyFromDB(o ?line2poly t ?endCapType 'ROUND ?holes t))
    when(axlPolyErrorGet() error("SOURCE25 source line polygon error\n"))
    own=append(own pc25Owned[o]) fprintf(f "%L\n" list(key row o pc25Owned[o] pc25OwnerChain(o)))) drain(f)
   ps=pc25Copy(ps) pc25WritePolys(key "SOURCE_ACTUAL_LINE" ps)
   relation=pc25PinRelation(ps nth(1 row) nth(2 row) ownf key "SOURCE")
   inside=pc13RingOp(ps car(relation) 'ANDNOT)
   fprintf(f "%L\n" list(key "WHOLE_SOURCE_LINE_OUTSIDE_OLD_SAME_NET_PAD_UNION" pc25Summary(inside))) drain(f)
   pc25WritePolys(key "SOURCE_LINE_OUTSIDE_OLD_SAME_NET_PADS" inside)
   ; Store detached polygons and plain identities only. No source DBID used later.
   pc25Frozen=cons(list(key row ps own cadr(relation) pc25Summary(inside) pc25Copy(car(relation))) pc25Frozen)
   pc25Step(sprintf(nil "SOURCE_KEY_%d_COMPLETE" key)))
  pc25Frozen=reverse(pc25Frozen) close(f) close(ownf) close(pc25PolyPort)
  unless(length(pc25Frozen)==25 && equal(pc25SourceDRC axlDBControl('drcEnable)) && equal(pc25SourceFill axlDBControl('dynamicFillMode)) error("SOURCE25 source readonly state changed\n"))
  pub403FullTypedGate(strcat(pub403Bundle "/SOURCE_FULL2698_WITH_NONLOGICAL_IDENTITIES.ilist"))
  pub403StateGate(strcat(pub403Bundle "/SOURCE_CONTROL_EXPECTED_ALL593_TEXT_PROPS.ilist"))
  f=outfile(strcat(dir "/SOURCE25_OWNER_PREPARE_COMPLETE.txt")) fprintf(f "SOURCE25_FULL_OWNER_PROPERTIES_OLD_ACTUAL_REGULAR_PAD_NATIVE_PROOF_COMPLETE\nNO_CREATE_NO_SAVE\n") close(f)
  pc25Step("SOURCE_COMPLETE_BEFORE_TOP_LEVEL_OPEN") close(pc25StepPort) t))
procedure(pub0010Source25Target(dir)
 let((f pf key row ps same missing relation outside oldDrc oldFill missingOutsideOld missingInsideNew failures)
  unless(length(pc25Frozen)==25 error("SOURCE25 detached original globals missing\n"))
  sstatus(fullPrecision t) pub403ReadUnits()
  oldDrc=axlDBControl('drcEnable) oldFill=axlDBControl('dynamicFillMode)
  pub403FullTypedGate(strcat(pub403Bundle "/TARGET_FULL2698_WITH_NONLOGICAL_IDENTITIES.ilist"))
  pub403StateGate(strcat(pub403Bundle "/SOURCE_CONTROL_EXPECTED_ALL593_TEXT_PROPS.ilist")) pub403AllNameGate(nil)
  pc25StepPort=outfile(strcat(dir "/TARGET_STEP.txt")) pc25Step("TARGET_BEGIN")
  pub0010BuildCuIndex() pc25MakePinOwners()
  unless(equal(pc25OriginalVias pub0010ViasSnapshot(strcat(dir "/TARGET_ALL1739_TYPED_VIAS.ilist"))) error("SOURCE25 target all1739 original typed vias differ\n"))
  f=outfile(strcat(dir "/SOURCE25_TARGET_WHOLE_CU_RELATIONS.ilist")) pf=outfile(strcat(dir "/SOURCE25_NEW_PAD_RELATIONS.ilist"))
  pc25PolyPort=outfile(strcat(dir "/SOURCE25_TARGET_ACTUAL_POLYGONS.jsonl")) failures=nil
  foreach(item pc25Frozen
   key=car(item) row=nth(1 item) ps=nth(2 item) same=nil
   foreach(poly ps same=append(same pc13NearbySameNetCopper(nth(1 row) nth(2 row) poly->bBox)))
   missing=pc13RingOp(ps same 'ANDNOT)
   pc25WritePolys(key "SOURCE_LINE_MISSING_FROM_TARGET_SAME_NET_TOTAL_CU" missing)
   relation=pc25PinRelation(ps nth(1 row) nth(2 row) pf key "TARGET")
   outside=pc13RingOp(ps car(relation) 'ANDNOT)
   pc25WritePolys(key "SOURCE_LINE_OUTSIDE_NEW_SAME_NET_PADS" outside)
   missingOutsideOld=pc13RingOp(missing nth(6 item) 'ANDNOT)
   missingInsideNew=pc13RingOp(missing car(relation) 'AND)
   pc25WritePolys(key "EXACT_MISSING_THERMAL_CU_OUTSIDE_DETACHED_OLD_ACTUAL_PAD" missingOutsideOld)
   pc25WritePolys(key "EXACT_MISSING_THERMAL_CU_INTERSECTION_NEW_ACTUAL_PAD" missingInsideNew)
   when(missingOutsideOld || missingInsideNew failures=cons(key failures))
   fprintf(f "%L\n" list(key row "OLD_SYMBOL_OWNERS" nth(3 item) "OLD_INTERSECTING_PIN_IDS" nth(4 item) "WHOLE_LINE" pc25Summary(ps) "SOURCE_LINE_OUTSIDE_OLD_PADS" nth(5 item) "TARGET_MISSING_SOURCE_CU" pc25Summary(missing) "SOURCE_LINE_OUTSIDE_NEW_PADS" pc25Summary(outside) "MISSING_THERMAL_OUTSIDE_OLD_ACTUAL_PAD" pc25Summary(missingOutsideOld) "MISSING_THERMAL_INSIDE_NEW_ACTUAL_PAD" pc25Summary(missingInsideNew))) drain(f)
   pc25Step(sprintf(nil "TARGET_KEY_%d_COMPLETE" key)))
  close(f) close(pf) close(pc25PolyPort)
  pub403FullTypedGate(strcat(pub403Bundle "/TARGET_FULL2698_WITH_NONLOGICAL_IDENTITIES.ilist"))
  pub403StateGate(strcat(pub403Bundle "/SOURCE_CONTROL_EXPECTED_ALL593_TEXT_PROPS.ilist")) pub403AllNameGate(nil)
  unless(equal(oldDrc axlDBControl('drcEnable)) && equal(oldFill axlDBControl('dynamicFillMode)) error("SOURCE25 target readonly state changed\n"))
  unless(null(failures) error("SOURCE25 bounded old-land thermal delta failed keys %L\n" failures))
  f=outfile(strcat(dir "/SOURCE25_PAD_RELATION_COMPLETE.txt")) fprintf(f "SOURCE25_OWNERSHIP_AND_OLD_NEW_REGULAR_PAD_NATIVE_RELATIONS_COMPLETE\nFULL2698_593_572_SOURCE_TEXT_PROPERTIES_EXACT\nALL1739_ORIGINAL_TYPED_VIAS_EXACT\nALL25_THERMAL_MISSING_OUTSIDE_OLD_ACTUAL_PAD_EMPTY\nALL25_MISSING_INTERSECTION_NEW_ACTUAL_PAD_EMPTY\nNO_CREATE_NO_SAVE_NO_UNBOUNDED_ACCEPTANCE\n") close(f)
  pc25Step("TARGET_COMPLETE_NO_CREATE_NO_SAVE") close(pc25StepPort) t))
