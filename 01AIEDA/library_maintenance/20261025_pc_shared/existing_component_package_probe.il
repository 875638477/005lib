procedure(pcPublicExistingComponentProbe(dir)
 let((f c props oldName oldPackage oldDevice oldCount result after)
  f=outfile(strcat(dir "/EXISTING_COMPONENT_PACKAGE_PROBE.ilist"))
  c=car(setof(x axlDBGetDesign()->components equal(x->name "C14")))
  unless(c error("Required C14 missing\n"))
  oldName=c->name oldPackage=c->package oldDevice=c->deviceType
  oldCount=length(axlDBGetDesign()->components)
  props=axlDBGetProperties(c->compdef '("user" "allegro"))
  fprintf(f "BEFORE=%L\nCOMPDEF_PROPS=%L\n" list(oldName oldPackage oldDevice c->??) props) drain(f)
  unless(axlWriteDeviceFile(c->compdef dir) error("Source device export failed\n"))
  axlSetVariable("devpath" dir)
  result=errset(axlDBCreateComponent(oldName oldDevice "c0603_pc" cadr(assoc('VALUE props)) cadr(assoc('TOL props))) t)
  after=car(setof(x axlDBGetDesign()->components equal(x->name oldName)))
  fprintf(f "RESULT=%L\nAFTER=%L\nCOUNT_BEFORE=%d\nCOUNT_AFTER=%d\n" result list(after->name after->package after->deviceType after->??) oldCount length(axlDBGetDesign()->components))
  fprintf(f "PROBE_COMPLETE_NO_EXPLICIT_SAVE\n") close(f)
 ))
