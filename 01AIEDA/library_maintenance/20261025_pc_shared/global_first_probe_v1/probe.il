load("D:/001DIY/004computer/lga1700/cadence_geometry_merge_20261025/psm_native_units.il")
procedure(psmNativePrepare(blank job)
 let((opened units accuracy extent f)
  f=outfile("D:/001DIY/005lib/01AIEDA/library_maintenance/20261025_pc_shared/global_first_probe_v1/step.txt") fprintf(f "BEFORE_OPEN\n") drain(f)
  opened=axlOpenDesignForBatch(blank "wfl")
  fprintf(f "AFTER_OPEN=%L\n" opened) drain(f)
  unless(opened error("Cannot open"))
  fprintf(f "SYMBOLS=%L PADS=%L\n" axlDBGetDesign()->symdefs axlDBGetDesign()->padstacks) drain(f)
  units=nth(2 job) accuracy=nth(3 job) extent=nth(4 job)
  fprintf(f "BEFORE_UNITS %L %L\n" units accuracy) drain(f)
  axlDBChangeDesignUnits(units accuracy)
  fprintf(f "AFTER_UNITS=%L\n" axlDBGetDesignUnits()) drain(f)
  fprintf(f "BEFORE_EXTENTS %L\n" extent) drain(f)
  unless(axlDBChangeDesignExtents(extent) error("Extents failed"))
  fprintf(f "AFTER_EXTENTS\n") close(f) t))
psmNativeBatch("D:/001DIY/005lib/01AIEDA/library_maintenance/20261025_pc_shared/global_first_probe_v1/blank.brd" '(("0402" "D:/001DIY/005lib/01AIEDA/library_maintenance/20261025_pc_shared/global_first_probe_v1/output/0000.sexp" "mils" 3 ((-573.550 -573.550) (592.550 592.550)))) "D:/001DIY/005lib/01AIEDA/library_maintenance/20261025_pc_shared/global_first_probe_v1/status.tsv" "D:/001DIY/005lib/01Psm_lib" "D:/001DIY/005lib/01Pad_lib")
