load("D:/001DIY/005lib/01AIEDA/library_maintenance/20261025_pc_shared/project6_mainfont_plan13_v2/mainfont_context.il")
load("D:/001DIY/004computer/lga1700/cadence_geometry_merge_20261025/psm_export.il")
procedure(pcSharedNativePrepareV2(blank job s skipOpen)
 let((opened units accuracy extent)
  if(skipOpen then
   fprintf(s "SKIP_FIRST_OPEN\t%L\t%L\n" car(job) blank) drain(s)
   opened=t
  else
   fprintf(s "BEFORE_OPEN\t%L\t%L\n" car(job) blank) drain(s)
   opened=axlOpenDesignForBatch(blank "wfl")
   fprintf(s "AFTER_OPEN\t%L\t%L\n" car(job) opened) drain(s))
  unless(opened error("Could not open alternating blank template"))
  unless(null(axlDBGetDesign()->symdefs) && null(axlDBGetDesign()->padstacks) error("Native template is not empty"))
  units=nth(2 job) accuracy=nth(3 job) extent=nth(4 job)
  fprintf(s "BEFORE_UNITS\t%L\t%L\t%L\n" car(job) units accuracy) drain(s)
  axlDBChangeDesignUnits(units accuracy)
  unless(equal(axlDBGetDesignUnits() list(units accuracy)) error("Native source units were not set"))
  fprintf(s "AFTER_UNITS\t%L\t%L\n" car(job) axlDBGetDesignUnits()) drain(s)
  unless(axlDBChangeDesignExtents(extent) error("Native source drawing extents were not set"))
  fprintf(s "AFTER_EXTENTS\t%L\n" car(job)) drain(s)
  pc13MainFontContextApply(s)
  t))
procedure(pcSharedNativeBatchV2(blankA blankB jobs status symbolPath padPath)
 let((s prepared result context severity prepSeverity i blank)
  sstatus(fullPrecision t)
  axlSetVariable("psmpath" symbolPath)
  axlSetVariable("padpath" padPath)
  s=outfile(status) i=0
  fprintf(s "BATCH_ENTER\tALTERNATING_IDENTICAL_EMPTY4\n") drain(s)
  foreach(job jobs
   blank=if(mod(i 2)==0 then blankA else blankB)
   fprintf(s "PREP_ENTER\t%L\t%L\n" car(job) i) drain(s)
   context=axlMsgContextStart(sprintf(nil "PSM PREP %s" car(job)))
   prepared=errset(pcSharedNativePrepareV2(blank job s i==0) t)
   prepSeverity=axlMsgContextTest(context)
   fprintf(s "PREP_MESSAGES\t%L\t%L\n" car(job) axlMsgContextGet(context))
   axlMsgContextFinish(context)
   fprintf(s "PREP_SEVERITY\t%L\t%L\n" car(job) prepSeverity)
   if(prepared && car(prepared) then
    context=axlMsgContextStart(sprintf(nil "PSM LOAD %s" car(job)))
    fprintf(s "BEGIN\t%L\t%L\n" car(job) axlDBGetDesignUnits()) drain(s)
    result=errset(psmAuditExport(car(job) cadr(job)) t)
    severity=axlMsgContextTest(context)
    fprintf(s "MESSAGES\t%L\t%L\n" car(job) axlMsgContextGet(context))
    axlMsgContextFinish(context)
    fprintf(s "SEVERITY\t%L\t%L\n" car(job) severity)
    fprintf(s "END\t%L\t%L\n" car(job) result)
   else fprintf(s "PREP_FAILED\t%L\t%L\n" car(job) prepared))
   i=i+1 drain(s))
  fprintf(s "COMPLETE\n") close(s) t))
