; SOURCE06B8 -> top-level OPEN TARGETA965, owned temporary copy only.
; Restore two exact original route net partitions before restoring missing U5 Cu.
load("D:/001DIY/004computer/lga1700/13shared_libraries_pc_20261025/w/pcb_migration/all81_source_cu_v5/all81_restore_actual_source_cu_v5.il")
procedure(pc13TagRouteRows(net layer source)
 let((result ps)
  result=nil
  foreach(index pc13CuIndexRows
   when(equal(nth(4 index) "path") && equal(nth(1 index) net) && equal(nth(2 index) layer)
    when(car(setof(p source pc13BoxesMeet(p->bBox nth(3 index))))
     ps=pc13IndexedCuPolys(index layer)
     when(pc13RingOp(ps source 'AND) result=cons(list(index ps) result))))) reverse(result)))
procedure(pc13TagSourceRow(net)
 let((rows)
  rows=setof(row pc13FrozenSourceCu equal(nth(1 row) net) && equal(nth(4 row) "REAL_SOURCE_ROUTE_SEGMENT") &&
   (equal(net "USB_FRONT__USB3_RXP4__AD17") || equal(car(row) "(\"line\" \"VDD10_1\" \"ETCH/TOP\" 8.0 (67860 52180) (67860 55860))")))
  when(equal(net "USB_FRONT__USB3_RXP4__AD17") rows=setof(row rows equal(car(row) "(\"line\" \"USB_FRONT__USB3_RXP4__AD17\" \"ETCH/TOP\" 4.5 (317440 -199780) (317440 -203220))")))
  unless(length(rows)==1 error("Exact source route-tag row missing %s\n" net)) car(rows)))
procedure(pc13SourceCu6Prepare(dir)
 let((row rows index o ps rp converted pf f keys)
  pc13SourceCuPrepare(dir)
  pc13CuStepPort=outfile(strcat(dir "/ROUTE_TAG_SOURCE_STEP.txt"))
  pc13FrozenUsbPaths=nil pc13FrozenUsbCu=nil
  row=pc13TagSourceRow("USB_FRONT__USB3_RXP4__AD17")
  rows=append(pc13TagRouteRows("USB_FRONT__USB3_RXP4__AD17" "ETCH/TOP" nth(3 row)) pc13TagRouteRows("USB3_RXP4" "ETCH/TOP" nth(3 row)))
  unless(length(rows)==3 error("Expected exact source USB bridge and two external paths\n"))
  f=outfile(strcat(dir "/SOURCE_USB3_ORIGINAL_PATHS.ilist")) pf=outfile(strcat(dir "/SOURCE_USB3_ORIGINAL_PATH_CU.jsonl"))
  foreach(item rows
   index=car(item) o=car(index) ps=cadr(item)
   unless(null(o->symbolEtch) && null(pc13Props(o)) error("USB source path owner/properties differ from frozen nil\n"))
   foreach(seg o->segments unless(null(pc13Props(seg)) error("Source USB segment properties require explicit copy support\n")))
   rp=axlDB2Path(o) unless(rp error("Official axlDB2Path source USB conversion failed\n"))
   converted=axlPolyFromDB(rp ?holes t ?line2poly t ?endCapType 'ROUND)
   when(axlPolyErrorGet() error("Detached source USB r_path Cu conversion failed\n")) converted=remove(nil converted)
   when(pc13RingOp(converted ps 'ANDNOT) || pc13RingOp(ps converted 'ANDNOT) error("Source r_path lost width/arc/full Cu\n"))
   pc13FrozenUsbPaths=cons(list(nth(1 index) nth(2 index) rp ps pc13Props(o) o->nSegs) pc13FrozenUsbPaths)
   pc13FrozenUsbCu=append(pc13FrozenUsbCu ps)
   fprintf(f "%L\n" list(nth(1 index) o->bBox pc13Props(o) o->??))
   foreach(seg o->segments fprintf(f "SEGMENT %L\n" seg->??))
   pc13RingWrite(pf nth(1 index) "ORIGINAL_FULL_SOURCE_USB_PATH" ps))
  close(f) close(pf) pc13FrozenUsbPaths=reverse(pc13FrozenUsbPaths)
  keys=sort(foreach(mapcar item pc13FrozenUsbPaths sprintf(nil "%s:%d" car(item) nth(5 item))) 'alphalessp)
  unless(equal(keys '("USB3_RXP4:10" "USB3_RXP4:6" "USB_FRONT__USB3_RXP4__AD17:1")) error("Frozen USB source three path identities changed %L\n" keys))
  pc13FrozenVddCu=nth(3 pc13TagSourceRow("VDD10_1"))
  pc13CuStep("FULL_SOURCE_USB_3PATH_RPATH_AND_CU_EXACT_PREPARED") close(pc13CuStepPort) t))
procedure(pc13SourceRouteTagRestore(dir)
 let((f pf bridge rows usb o targetCu vdd vddRows source result created actual count all newCu beforeSegments)
  unless(length(pc13FrozenUsbPaths)==3 && pc13FrozenUsbCu && pc13FrozenVddCu error("Source route-tag globals unavailable\n"))
  pc13CuStepPort=outfile(strcat(dir "/ROUTE_TAG_TARGET_STEP.txt")) pc13BuildCuIndex("TARGET_ROUTE_TAG_PREFLIGHT")
  bridge=nth(3 pc13TagSourceRow("USB_FRONT__USB3_RXP4__AD17"))
  rows=pc13TagRouteRows("USB3_RXP4" "ETCH/TOP" bridge)
  unless(length(rows)==1 error("Expected one merged target USB path\n")) usb=caar(rows) o=car(usb) targetCu=cadar(rows)
  unless(o->nSegs==15 && null(o->symbolEtch) && null(pc13Props(o)) error("Merged USB target path signature changed\n"))
  when(pc13RingOp(targetCu pc13FrozenUsbCu 'ANDNOT) || pc13RingOp(pc13FrozenUsbCu targetCu 'ANDNOT) error("Source3 USB path union differs from current merged15 physical Cu; no delete allowed\n"))
  vddRows=append(pc13TagRouteRows(nil "ETCH/TOP" pc13FrozenVddCu) pc13TagRouteRows("VDD10_1" "ETCH/TOP" pc13FrozenVddCu))
  vddRows=setof(item vddRows null(pc13RingOp(cadr(item) pc13FrozenVddCu 'ANDNOT)) && null(pc13RingOp(pc13FrozenVddCu cadr(item) 'ANDNOT)))
  unless(length(vddRows)==1 error("Original VDD line no longer physically exact\n")) vdd=caaar(vddRows)
  unless(vdd->nSegs==1 && null(vdd->symbolEtch) && null(pc13Props(vdd)) error("Original VDD line owner/properties/segments differ\n"))
  ; Every mutation below is now bounded by exact original positive Cu.
  f=outfile(strcat(dir "/ROUTE_TAG_REPAIR.tsv")) pf=outfile(strcat(dir "/ROUTE_TAG_PHYSICAL_CU.jsonl"))
  fprintf(f "USB_SOURCE3_TARGET15_TOTAL_CU_ANDNOT_BOTH_DIRECTIONS_EMPTY\n") drain(f)
  pc13RingWrite(pf "USB_SOURCE3" "SOURCE_FULL_PHYSICAL_CU" pc13FrozenUsbCu)
  pc13RingWrite(pf "USB_TARGET15" "TARGET_BEFORE_PHYSICAL_CU" targetCu)
  ; Delete only the fifteen guarded line/arc segments, never branch/via/net.
  beforeSegments=o->segments
  unless(length(beforeSegments)==15 error("USB exact deletion set changed\n"))
  foreach(seg beforeSegments unless(member(seg->objType '("line" "arc")) && null(pc13Props(seg)) error("USB source segment unsupported owner/properties\n")))
  unless(axlDeleteObject(beforeSegments) error("Official exact USB fifteen-segment deletion failed\n"))
  count=0
  foreach(item pc13FrozenUsbPaths
   result=axlDBCreatePath(nth(2 item) nth(1 item) car(item)) unless(result && car(result) error("Exact original USB path recreation failed\n"))
   actual=nil
   foreach(obj car(result)
    axlDBRefreshId(obj)
    unless(equal(obj->net->name car(item)) && null(pc13Props(obj)) && null(obj->symbolEtch) error("Recreated original USB path wrong typed net/props/owner\n"))
    actual=append(actual axlPolyFromDB(obj ?holes t ?endCapType 'ROUND)) when(axlPolyErrorGet() error("Recreated USB Cu conversion failed\n")))
   actual=remove(nil actual)
   when(pc13RingOp(actual nth(3 item) 'ANDNOT) || pc13RingOp(nth(3 item) actual 'ANDNOT) error("Recreated original USB path width/arc/Cu differs\n"))
   count=count+1 fprintf(f "USB_PATH_ORIGINAL_NET_RESTORED\t%s\t%d\tCUPOLY_EXACT\n" car(item) nth(5 item)) drain(f)
   pc13RingWrite(pf car(item) "RESTORED_ORIGINAL_FULL_PATH_CU" actual))
  ; Original VDD positive copper already exists on nativeNIL. A same-net
  ; source-identical filled anchor adds zero material and permits native re-net.
  when(null(vdd->net->name)
   foreach(poly pc13FrozenVddCu
    result=axlDBCreateShape(poly t "ETCH/TOP" "VDD10_1" nil) unless(result && car(result) error("Original VDD Cu-contained net anchor failed\n"))
    created=car(result) axlDBRefreshId(created)
    actual=axlPolyFromDB(created ?holes t) when(axlPolyErrorGet() error("Original VDD anchor Cu conversion failed\n")) actual=remove(nil actual)
    when(pc13RingOp(actual list(poly) 'ANDNOT) || pc13RingOp(list(poly) actual 'ANDNOT) error("VDD original Cu anchor differs\n"))))
  axlDBRefreshId(nil) pc13BuildCuIndex("AFTER_ORIGINAL_ROUTE_TAG_RESTORE")
  foreach(item pc13FrozenUsbPaths foreach(poly nth(3 item)
   unless(null(pc13RingOp(list(poly) pc13NearbySameNetCopper(car(item) nth(1 item) poly->bBox) 'ANDNOT)) error("Original USB source route net portion was not retained\n"))))
  foreach(poly pc13FrozenVddCu
   unless(null(pc13RingOp(list(poly) pc13NearbySameNetCopper("VDD10_1" "ETCH/TOP" poly->bBox) 'ANDNOT)) error("Original VDD source net not restored\n")))
  pc13AllPinGate("D:/001DIY/004computer/lga1700/13shared_libraries_pc_20261025/w/pcb_migration/all81_migration_v7/TARGET_PINS6521.ilist")
  fprintf(f "VDD_SOURCE_NET_ANCHOR_PHYSICAL_ADDED_CU_ZERO\nSOURCE_USB_PREEXISTING_ALIAS_CONTACT_RETAINED_NOT_NEW_SHORT\nALL6521_TYPED_PINS_UNCHANGED\n")
  close(f) close(pf) pc13CuStep("ORIGINAL_ROUTE_TAG_RESTORE_COMPLETE") close(pc13CuStepPort) count))
procedure(pc13SourceCu6Restore(dir)
 let((oldDrc oldFill poses texts props result f count)
  oldDrc=axlDBControl('drcEnable) oldFill=axlDBControl('dynamicFillMode)
  poses=makeTable('pc13RouteBeforePose nil) texts=makeTable('pc13RouteBeforeText nil) props=makeTable('pc13RouteBeforeProps nil)
  count=0 foreach(c axlDBGetDesign()->components count=count+1 poses[c->name]=pc13Pose(c->symbol) texts[c->name]=pc13TextSorted(c->symbol) props[c->name]=pc13Props(c->compdef))
  unless(count==1066 error("Original route repair full1066 snapshot count failed\n"))
  pc13AllPinGate("D:/001DIY/004computer/lga1700/13shared_libraries_pc_20261025/w/pcb_migration/all81_migration_v7/TARGET_PINS6521.ilist")
  pc13SourceRouteTagRestore(dir)
  unless(equal(oldDrc axlDBControl('drcEnable)) && equal(oldFill axlDBControl('dynamicFillMode)) error("Original route repair altered DRC/fill state\n"))
  result=pc13SourceCuRestore(dir)
  foreach(c axlDBGetDesign()->components
   unless(equal(poses[c->name] pc13Pose(c->symbol)) && equal(texts[c->name] pc13TextSorted(c->symbol)) && equal(props[c->name] pc13Props(c->compdef)) error("Route-tag repair altered source1066 pose/text/properties\n")))
  f=outfile(strcat(dir "/SOURCE_CU_V6_COMPLETE.txt")) fprintf(f "ORIGINAL_USB3_PATH_NET_PARTITIONS_RECREATED_PHYSICAL_UNION_EXACT\nORIGINAL_VDD_EXISTING_CU_SOURCE_NET_RESTORED\nSOURCE6521_TYPED_PINS_AND1066_POSE_TEXT_PROPS_UNCHANGED\nORIGINAL_SOURCE_CU_RESTORE_GATE_PASSED\n") close(f) result))
