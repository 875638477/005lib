; Prepared case wrapper, not yet natively executed. Root owns isolated Allegro jobs.
; Explicit bundle input, strict original millimeters4, never source49AF mils2.
unless(boundp('pub403Bundle) error("PUB403 explicit bundle path required\n"))
load(strcat(pub403Bundle "/pc13_native_replace_base572.il"))

procedure(pub403Rows(path)
 let((f row rows)
  rows=nil f=infile(path) unless(f error("PUB403 expected ledger missing %s\n" path))
  while(row=lineread(f) rows=cons(car(row) rows)) close(f) reverse(rows)))
procedure(pub403ReadUnits()
 unless(equal(axlDBGetDesignUnits() '("millimeters" 4)) error("PUB403 requires original millimeters4 units and grid\n")) t)
procedure(pub403Identity(s)
 let((c) c=s->component
  list(if(s->refdes then "LOGICAL" else "NONLOGICAL") s->refdes if(c then c->name else nil) s->name s->definition->name s->xy s->rotation s->isMirrored)))
procedure(pub403SameIdentity(s id ignoreLogicalName)
 let((a)
  a=pub403Identity(s)
  equal(car(a) car(id)) && equal(nth(1 a) nth(1 id)) && equal(nth(2 a) nth(2 id)) &&
  equal(nth(5 a) nth(5 id)) && equal(nth(6 a) nth(6 id)) && equal(nth(7 a) nth(7 id)) &&
  (ignoreLogicalName && equal(car(id) "LOGICAL") ||
   equal(upperCase(nth(3 a)) upperCase(nth(3 id))) && equal(upperCase(nth(4 a)) upperCase(nth(4 id))))))
procedure(pub403FullTypedGate(path)
 let((rows used count row id s expected p consumed actualCount)
  pub403ReadUnits() rows=pub403Rows(path) used=nil count=0
  unless(length(rows)==593 && length(axlDBGetDesign()->symbols)==593 && length(axlDBGetDesign()->components)==572 error("PUB403 full593symbols/572components coverage failed\n"))
  foreach(row rows
   id=car(row) expected=cadr(row)
   unless(length(row)==2 && length(id)==9 error("PUB403 full identity ledger schema invalid\n"))
   s=car(setof(q axlDBGetDesign()->symbols !member(q used) && pub403SameIdentity(q id nil)))
   unless(s error("PUB403 source/target symbol identity missing %L\n" id))
   used=cons(s used) consumed=nil
   unless(length(expected)==length(s->pins) error("PUB403 physical pin count differs %L\n" id))
   foreach(pr expected
    p=car(setof(q s->pins !member(q consumed) && equal(q->number car(pr)) && equal(q->xy cadr(pr))))
    unless(p error("PUB403 physical pin not found %L %L\n" id pr)) consumed=cons(p consumed)
    unless(length(pr)==6 && equal(p->net->name nth(2 pr)) && equal(p->isMech nth(3 pr)) && equal(p->isThrough nth(4 pr)) && equal(p->name nth(5 pr)) && null(p->isExploded)
     error("PUB403 physical pin typed attributes differ %L %L\n" id pr)) count=count+1))
  unless(length(used)==593 && count==2698 error("PUB403 all2698 typed pin coverage failed\n")) count))
procedure(pub403SnapshotAll(path)
 let((f c s id usedBlocks textRec block)
  f=outfile(path) usedBlocks=nil
  foreach(s axlDBGetDesign()->symbols
   id=pub403Identity(s) textRec=pc13TextSnapshot(s)
   fprintf(f "%L\n" list("symbol" id textRec pc13Props(s)))
   foreach(row textRec block=nth(6 row) unless(member(block usedBlocks) usedBlocks=cons(block usedBlocks))))
  foreach(c axlDBGetDesign()->components fprintf(f "%L\n" list("component" c->name pc13Props(c) pc13Props(c->compdef))))
  foreach(block usedBlocks fprintf(f "%L\n" list("textblock" block axlGetParam(strcat("paramTextBlock:" block))->??)))
  close(f) t))
procedure(pub403StateGate(path)
 let((rows used s c count components row id)
  rows=pub403Rows(path) used=nil count=0 components=0
  foreach(row rows
   cond(
    (equal(car(row) "symbol")
     id=cadr(row) s=car(setof(q axlDBGetDesign()->symbols !member(q used) && pub403SameIdentity(q id t)))
     unless(s error("PUB403 snapshot symbol missing %L\n" id)) used=cons(s used)
     unless(equal(sort(foreach(mapcar x nth(2 row) sprintf(nil "%L" x)) 'alphalessp) pc13TextSorted(s)) error("PUB403 full symbol owned text changed %L\n" id))
     unless(equal(nth(3 row) pc13Props(s)) error("PUB403 full symbol properties changed %L\n" id)) count=count+1)
    (equal(car(row) "component")
     c=pc13Comp(cadr(row)) unless(c && equal(nth(2 row) pc13Props(c)) && equal(nth(3 row) pc13Props(c->compdef)) error("PUB403 component/compdef properties changed %L\n" cadr(row))) components=components+1)
    (equal(car(row) "textblock") unless(equal(nth(2 row) axlGetParam(strcat("paramTextBlock:" cadr(row)))->??) error("PUB403 used global text block definition changed %L\n" cadr(row))))
    (t error("PUB403 unknown snapshot row kind\n"))))
  unless(count==593 && components==572 error("PUB403 full593text/props and572component props snapshot coverage failed\n")) t))
procedure(pub403AllNameGate(physicalOnly)
 let((f line fields count c from target)
  f=infile(strcat(pub403Bundle "/ALL572_APPROVED.tsv")) unless(f error("PUB403 full-name manifest missing\n")) gets(line f) count=0
  while(gets(line f)
   fields=parseString(line "\t\r\n") unless(length(fields)==4 error("PUB403 full-name manifest malformed\n"))
   c=pc13Comp(car(fields)) from=upperCase(cadr(fields)) target=upperCase(caddr(fields))
   unless(c && c->symbol && equal(upperCase(c->symbol->name) target) && equal(upperCase(c->symbol->definition->name) target) error("PUB403 approved physical definition name mismatch %L\n" fields))
   if(physicalOnly then
    unless(member(upperCase(c->package) list(from target)) error("PUB403 unexpected logical package during Alt stage %L\n" fields))
   else unless(equal(upperCase(c->package) target) error("PUB403 final logical package not synchronized %L\n" fields))) count=count+1)
  close(f) unless(count==572 error("PUB403 all572 approved name coverage failed\n")) t))
procedure(pub403DiagRow(f tag o)
 when(o fprintf(f "%s\t%L\t%L\t%L\t%L\t%L\t%L\t%L\t%L\t%L\t%L\t%L\t%L\t%L\n"
  tag o o->objType o->net->name o->component->name o->number o->xy o->layer o->startEnd o->width o->bBox o->parent o->parent->net->name o->nSegs)))
procedure(pub403Adjacency(phase dir)
 let((rows f pf selection c p xy neighbors n ends index side endobj shape indirect count)
  pub403ReadUnits() unless(member(phase '("source" "target")) error("PUB403 adjacency phase invalid\n"))
  rows=pub403Rows(strcat(pub403Bundle "/CHANGED806_SOURCE_TARGET_XY.ilist")) unless(length(rows)==806 error("PUB403 expects806 actual physical pin selections\n"))
  f=outfile(strcat(dir "/PUB403_" phase "_pin_adjacency.ilist")) pf=outfile(strcat(dir "/PUB403_" phase "_pin_adjacency_summary.tsv")) count=0
  fprintf(f "context\tdbid\tkind\tnet\trefdes\tpin\txy\tlayer\tstartEnd\twidth\tbBox\tparent\tparent_net\tnSegs\n")
  fprintf(pf "refdes\tpin\txy\tnet\tdirect_connected_count\tdirect_kinds\n")
  foreach(selection rows
   c=pc13Comp(car(selection)) xy=if(equal(phase "source") then nth(2 selection) else nth(3 selection))
   p=car(setof(q c->symbol->pins equal(q->number cadr(selection)) && equal(q->xy xy)))
   unless(p error("PUB403 selected physical pin missing %L\n" selection))
   fprintf(f "BEGIN_PIN %L\n" selection) pub403DiagRow(f "TARGET" p) neighbors=axlDBGetConnect(p t)
   fprintf(f "DIRECT_CONNECT %L\n" neighbors)
   fprintf(pf "%s\t%s\t%L\t%L\t%d\t%L\n" car(selection) cadr(selection) p->xy p->net->name length(neighbors) foreach(mapcar q neighbors q->objType))
   foreach(n neighbors
    pub403DiagRow(f "DIRECT_NEIGHBOR" n)
    when(member(n->objType '("path" "cline" "line" "arc"))
     foreach(seg n->segments pub403DiagRow(f "DIRECT_PATH_SEGMENT" seg)) ends=axlDBGetConnect(n t)
     fprintf(f "DIRECT_PATH_ENDPOINT_CONNECTIONS %L\n" ends)
     when(listp(car(ends)) index=0 foreach(side ends index=index+1 foreach(endobj side pub403DiagRow(f sprintf(nil "PATH_END_%d" index) endobj)))))
    when(equal(n->objType "shape")
     fprintf(f "DIRECT_SHAPE_PROPERTIES %L\n" n->??)
     indirect=n->connect
     foreach(path indirect
      when(member(path->objType '("path" "cline" "line" "arc")) && equal(path->net->name p->net->name)
       pub403DiagRow(f "INDIRECT_OWN_NET_PATH" path)
       foreach(seg path->segments pub403DiagRow(f "INDIRECT_PATH_SEGMENT" seg))
       fprintf(f "INDIRECT_PATH_PROPERTIES %L\n" path->??)))))
   fprintf(f "END_PIN %L\n" selection) drain(f) drain(pf) count=count+1)
  fprintf(f "PUB403_ALL806_ADJACENCY_COMPLETE PHASE=%s\n" phase) close(f) close(pf) count))
procedure(pub403SourceOnly(dir)
 let((f)
  sstatus(fullPrecision t) pub403FullTypedGate(strcat(pub403Bundle "/SOURCE_FULL2698_WITH_NONLOGICAL_IDENTITIES.ilist"))
  pub403SnapshotAll(strcat(dir "/SOURCE_ALL593_TEXT_PROPS.ilist")) pub403Adjacency("source" dir)
  f=outfile(strcat(dir "/PUB403_SOURCE_COMPLETE.txt")) fprintf(f "SOURCE_680500_FULL2698_593SYMBOLS_572COMPONENTS_806ADJACENCY_NO_SAVE\n") close(f) t))
procedure(pub403TargetOnly(dir)
 let((f count)
  sstatus(fullPrecision t) pub403FullTypedGate(strcat(pub403Bundle "/TARGET_FULL2698_WITH_NONLOGICAL_IDENTITIES.ilist"))
  count=pub403Adjacency("target" dir) unless(count==806 error("PUB403 target806 adjacency incomplete\n"))
  f=outfile(strcat(dir "/TARGET_ADJACENCY_ONLY_COMPLETE.txt")) fprintf(f "TARGET806_NATIVE_ADJACENCY_COMPLETE\n") close(f) count))
procedure(pub403Apply(dir)
 let((count snapshot f oldDrc)
  sstatus(fullPrecision t) pub403ReadUnits() oldDrc=axlDBControl('drcEnable)
  pub403FullTypedGate(strcat(pub403Bundle "/SOURCE_FULL2698_WITH_NONLOGICAL_IDENTITIES.ilist"))
  snapshot=strcat(dir "/SOURCE_ALL593_TEXT_PROPS.ilist") pub403SnapshotAll(snapshot)
  printf("PUB403_BOUND_SOURCE806_EVIDENCE_REUSED_NO_REPROBE\n")
  pub403Debug=outfile(strcat(dir "/REF_STAGE_DEBUG.ilist"))
  count=pc13Replace(strcat(pub403Bundle "/MIGRATE403.tsv") dir strcat(dir "/PUB0010_ALT403.brd") "D:/001DIY/005lib/01Psm_lib" "D:/001DIY/005lib/01Pad_lib" 0 strcat(pub403Bundle "/TARGET_LOGICAL572_EXPECTED_PINS.ilist"))
  unless(count==403 error("PUB403 expected exactly403 physical replacements\n"))
  pub403FullTypedGate(strcat(pub403Bundle "/TARGET_FULL2698_WITH_NONLOGICAL_IDENTITIES.ilist")) pub403StateGate(snapshot) pub403AllNameGate(t)
  unless(equal(oldDrc axlDBControl('drcEnable)) error("PUB403 source DRC enable state changed\n"))
  pub403Adjacency("target" dir) close(pub403Debug)
  f=outfile(strcat(dir "/PUB403_APPLY_COMPLETE.txt")) fprintf(f "ALT403_SOURCE_TARGET_FULL2698_593SYMBOLS_572TEXTS_AND_NONLOGICAL21_PROPS_PASSED\nLOGICAL_IFSAME_AND_FULLGETCONNECT_COPPER_CFX_GATES_STILL_REQUIRED\n") close(f) count))
procedure(pub403Fresh(snapshot dir)
 let((f)
  sstatus(fullPrecision t) pub403FullTypedGate(strcat(pub403Bundle "/TARGET_FULL2698_WITH_NONLOGICAL_IDENTITIES.ilist"))
  pub403StateGate(snapshot) pub403AllNameGate(nil) pc13WriteMetadata(dir "fresh") pub403Adjacency("target" dir)
  f=outfile(strcat(dir "/PUB403_FRESH_COMPLETE.txt")) fprintf(f "FRESH_TARGET2698_FULL593_TEXT_PROPS_572_LOGICAL_NAMES_COMPLETE_NO_SAVE\nFULLGETCONNECT915_AND_COPPER_CFX_GATES_ARE_SEPARATE_REQUIRED_PROOFS\n") close(f) t))

; Diagnostic v2: trace inside cloak so the exact per-ref error is not masked by nil.
procedure(pub403Trace(ref stage)
 let((c s pins)
  c=pc13Comp(ref) s=c->symbol
  pins=foreach(mapcar p s->pins list(p->number p->xy p->name p->net->name p->isMech p->isThrough p->isExploded))
  fprintf(pub403Debug "%L\n" list(ref stage c->package s->name s->definition->name pc13Pose(s) "EXPECTED_TARGET" pc13Expected[ref] "ACTUAL_PINS" pins "COMPDEF_PROPS" pc13Props(c->compdef) "COMP_PROPS" pc13Props(c) "SYMBOL_PROPS" pc13Props(s) "TEXT" pc13TextSnapshot(s))) drain(pub403Debug)
  printf("PUB403_REF_STAGE %s %s\n" ref stage) t))
procedure(pc13ReplaceOne(row f)
 let((ref from target c s pose texts props oldalt delta)
  ref=car(row) from=cadr(row) target=caddr(row) c=pc13Comp(ref) s=c->symbol
  pose=pc13Pose(s) texts=pc13TextSnapshot(s) props=pc13Props(c->compdef)
  pub403Trace(ref "BEFORE_ALT_PROP") oldalt=assoc('ALT_SYMBOLS props)
  unless(axlDBAddProp(list(c->compdef) list("ALT_SYMBOLS" strcat("(" target ")"))) error("PUB403 ALT_SYMBOLS add failed %s\n" ref))
  pub403Trace(ref "BEFORE_ALT_REPLACE")
  unless(axlAltSymbolReplace(c target) error("PUB403 Alt replace returnednil %s\n" ref))
  axlDBRefreshId(nil) c=pc13Comp(ref) s=c->symbol pub403Trace(ref "AFTER_ALT_BEFORE_MIRROR_RESTORE")

  ; Alt may reset a source bottom symbol to top. Restore side before text coordinates.
  unless(equal(s->isMirrored nth(2 pose))
   unless(axlTransformObject(s ?mirror t ?origin car(pose)) error("PUB403 source mirror restore failed %s\n" ref))
   axlDBRefreshId(nil) c=pc13Comp(ref) s=c->symbol pub403Trace(ref "AFTER_SOURCE_MIRROR_RESTORE"))
  unless(equal(s->xy car(pose)) error("PUB403 mirror changed source XY %s\n" ref))
  delta=cadr(pose)-s->rotation
  unless(zerop(delta)
   unless(axlTransformObject(s ?angle delta ?origin car(pose)) error("PUB403 source angle restore failed %s\n" ref))
   axlDBRefreshId(nil) c=pc13Comp(ref) s=c->symbol pub403Trace(ref "AFTER_SOURCE_ANGLE_RESTORE"))
  unless(equal(pose pc13Pose(s)) error("PUB403 source pose could not be restored %s\n" ref))
  pc13TextRestore(s texts) pub403Trace(ref "AFTER_TEXT_BEFORE_ALT_PROP_RESTORE")
  if(oldalt then axlDBAddProp(list(c->compdef) list("ALT_SYMBOLS" cadr(oldalt))) else axlDBDeleteProp(c->compdef "ALT_SYMBOLS"))
  axlDBRefreshId(nil) c=pc13Comp(ref) s=c->symbol pub403Trace(ref "AFTER_ALT_PROP_BEFORE_POSE")
  unless(equal(pose pc13Pose(s)) error("PUB403 pose changed %s\n" ref))
  pub403Trace(ref "BEFORE_EXPECTED_PINS") pc13ExpectedPins(ref s) pub403Trace(ref "AFTER_EXPECTED_PINS_BEFORE_TEXT_GUARD")
  unless(equal(sort(foreach(mapcar r texts sprintf(nil "%L" r)) 'alphalessp) pc13TextSorted(s)) error("PUB403 text changed %s\n" ref))
  unless(equal(props pc13Props(c->compdef)) error("PUB403 compdef props/ALT changed %s\n" ref))
  pub403Trace(ref "ALL_PER_REF_GUARDS_PASS") fprintf(f "%s\t%s\t%s\tTRUE\n" ref from target) drain(f) t))
procedure(pc13ReplaceRows(rows f)
 let((count row result)
  count=0
  foreach(row rows
   result=errset(pc13ReplaceOne(row f) t)
   unless(result && car(result)
    pub403Trace(car(row) "PER_REF_ERRSET_REJECTED")
    error("PUB403 detailed per-ref migration failed %s; preserve REF_STAGE_DEBUG.ilist\n" car(row)))
   count=count+1)
  count))

procedure(pub403Canary(dir)
 let((snapshot f result row c)
  sstatus(fullPrecision t) pub403ReadUnits()
  pub403FullTypedGate(strcat(pub403Bundle "/SOURCE_FULL2698_WITH_NONLOGICAL_IDENTITIES.ilist"))
  snapshot=strcat(dir "/SOURCE_ALL593_TEXT_PROPS.ilist") pub403SnapshotAll(snapshot)
  unless(axlSetVariable("psmpath" "D:/001DIY/005lib/01Psm_lib") error("PUB403 canary public PSMPATH failed\n"))
  unless(axlSetVariable("padpath" "D:/001DIY/005lib/01Pad_lib") error("PUB403 canary public PADPATH failed\n"))
  pc13LoadExpected(strcat(pub403Bundle "/TARGET_LOGICAL572_EXPECTED_PINS.ilist"))
  pub403Debug=outfile(strcat(dir "/REF_STAGE_DEBUG.ilist")) f=outfile(strcat(dir "/applied.tsv"))
  fprintf(f "refdes\tfrom_package\ttarget_package\tpose_pin_text_preserved\n")
  row=list("C90" "C0805" "c0805_pc" 0.0)
  result=axlDBCloak('pc13ReplaceRows(list(row) f) 'shape)
  unless(result==1 error("PUB403 singleC90 cloak failed\n")) close(f) close(pub403Debug)
  pub403FullTypedGate(strcat(pub403Bundle "/CANARY_C90_FULL2698.ilist")) pub403StateGate(snapshot)
  c=pc13Comp("C90") unless(equal(upperCase(c->symbol->name) "C0805_PC") && equal(upperCase(c->symbol->definition->name) "C0805_PC") error("PUB403 C90 targetphysical name failed\n"))
  unless(axlSaveDesign(?design strcat(dir "/PUB0010_CANARY_C90.brd") ?noMru t ?noConfirm t) error("PUB403 C90 canary save failed\n"))
  f=outfile(strcat(dir "/PUB403_CANARY_COMPLETE.txt")) fprintf(f "C90_SOURCE_SIDE_POSE_RESTORED_ALL2698_MIXED_TYPED_PINS_FULL593TEXT_PROPS_COMPLETE\nNO_FULL403_OR_CONNECTION_APPROVAL\n") close(f) t))

procedure(pub403NoOpSave(dir)
 let((f)
  sstatus(fullPrecision t) pub403ReadUnits()
  pub403FullTypedGate(strcat(pub403Bundle "/SOURCE_FULL2698_WITH_NONLOGICAL_IDENTITIES.ilist"))
  pub403SnapshotAll(strcat(dir "/CONTROL_BEFORE_ALL593_TEXT_PROPS.ilist")) pc13WriteMetadata(dir "control_before")
  unless(axlSaveDesign(?design strcat(dir "/SOURCE_NOOP_SAVE.brd") ?noMru t ?noConfirm t) error("PUB403 source control save failed\n"))
  axlDBRefreshId(nil)
  pub403FullTypedGate(strcat(pub403Bundle "/SOURCE_FULL2698_WITH_NONLOGICAL_IDENTITIES.ilist"))
  pub403SnapshotAll(strcat(dir "/CONTROL_AFTER_ALL593_TEXT_PROPS.ilist")) pc13WriteMetadata(dir "control_after")
  f=outfile(strcat(dir "/PUB403_NOOP_SAVE_COMPLETE.txt")) fprintf(f "ORIGINAL_SOURCE680500_NOOP_SAVEAS_ALL2698_TYPED_FULL593_SNAPSHOT_BEFORE_AFTER_COMPLETE\nNO_TEXT_DIFFERENCE_APPROVAL\n") close(f) t))
procedure(pub403ControlFresh(dir)
 let((f)
  sstatus(fullPrecision t) pub403ReadUnits()
  pub403FullTypedGate(strcat(pub403Bundle "/SOURCE_FULL2698_WITH_NONLOGICAL_IDENTITIES.ilist"))
  pub403SnapshotAll(strcat(dir "/CONTROL_FRESH_ALL593_TEXT_PROPS.ilist")) pc13WriteMetadata(dir "control_fresh")
  f=outfile(strcat(dir "/PUB403_CONTROL_FRESH_COMPLETE.txt")) fprintf(f "SOURCE_NOOP_SAVED_FRESH_FULL2698_FULL593_SNAPSHOT_COMPLETE_NO_SAVE\nNO_TEXT_DIFFERENCE_APPROVAL\n") close(f) t))

procedure(pub403TextRecord(ch)
 list(ch->text ch->xy ch->rotation ch->isMirrored ch->justify ch->layer ch->textBlock pc13Props(ch)))
procedure(pub403RestoreTextsSelective(s records)
 let((texts used pending rec ch orient result extra)
  texts=setof(q s->children equal(q->objType "text")) used=nil pending=nil
  ; Reserve every exact original readonly/static text before matching any changed text.
  foreach(rec records
   ch=car(setof(q texts !member(q used) && equal(pub403TextRecord(q) rec)))
   if(ch then used=cons(ch used) else pending=cons(rec pending)))
  foreach(rec reverse(pending)
   ch=car(setof(q texts !member(q used) && equal(q->layer nth(5 rec))))
   orient=make_axlTextOrientation(?textBlock nth(6 rec) ?rotation nth(2 rec) ?mirrored nth(3 rec) ?justify nth(4 rec))
   if(ch then
    used=cons(ch used)
    unless(axlDBChangeText(ch car(rec) orient) error("PUB403 postnetrev text change failed\n")) axlDBRefreshId(ch)
    unless(axlTransformObject(ch ?move list(xCoord(cadr(rec))-xCoord(ch->xy) yCoord(cadr(rec))-yCoord(ch->xy))) error("PUB403 postnetrev text move failed\n"))
   else
    result=axlDBCreateText(car(rec) cadr(rec) orient nth(5 rec) s) unless(result error("PUB403 postnetrev text create failed\n"))
    ch=car(result) when(listp(ch) ch=car(ch)))
   unless(equal(pc13Props(ch) nth(7 rec)) error("PUB403 postnetrev text property differs from exact source\n")))
  foreach(extra texts unless(member(extra used) unless(axlDeleteObject(extra) error("PUB403 unexpected text removal failed\n"))))
  axlDBRefreshId(s) foreach(ch s->children axlDBRefreshId(ch))
  unless(equal(sort(foreach(mapcar q records sprintf(nil "%L" q)) 'alphalessp) pc13TextSorted(s)) error("PUB403 selective text exact multiset failed\n")) t))
procedure(pub403PostNetrevRestore(dir)
 let((rows used row id s count f snapshot)
  sstatus(fullPrecision t) pub403ReadUnits()
  pub403FullTypedGate(strcat(pub403Bundle "/TARGET_FULL2698_WITH_NONLOGICAL_IDENTITIES.ilist")) pub403AllNameGate(nil)
  snapshot=strcat(pub403Bundle "/SOURCE_CONTROL_EXPECTED_ALL593_TEXT_PROPS.ilist") rows=pub403Rows(snapshot) used=nil count=0
  pub403SnapshotAll(strcat(dir "/POSTNETREV_BEFORE_ALL593_TEXT_PROPS.ilist"))
  foreach(row rows when(equal(car(row) "symbol")
   id=cadr(row) s=car(setof(q axlDBGetDesign()->symbols !member(q used) && pub403SameIdentity(q id t)))
   unless(s error("PUB403 postnetrev source pose/symbol missing %L\n" id)) used=cons(s used)
   pub403RestoreTextsSelective(s nth(2 row)) count=count+1))
  unless(count==593 error("PUB403 postnetrev all593 text restore coverage failed\n"))
  ; Component/compdef/symbol user+allegro props and source fonts remain exact gates.
  ; No generic property deletion/addition is performed by this text restoration.
  pub403StateGate(snapshot) pub403FullTypedGate(strcat(pub403Bundle "/TARGET_FULL2698_WITH_NONLOGICAL_IDENTITIES.ilist")) pub403AllNameGate(nil)
  pub403SnapshotAll(strcat(dir "/POSTNETREV_RESTORED_ALL593_TEXT_PROPS.ilist")) pc13WriteMetadata(dir "postnetrev_restored")
  unless(axlSaveDesign(?design strcat(dir "/PUB0010_NETREV_RESTORED.brd") ?noMru t ?noConfirm t) error("PUB403 postnetrev restored candidate save failed\n"))
  axlDBRefreshId(nil) pub403StateGate(snapshot) pub403FullTypedGate(strcat(pub403Bundle "/TARGET_FULL2698_WITH_NONLOGICAL_IDENTITIES.ilist")) pub403AllNameGate(nil)
  pub403SnapshotAll(strcat(dir "/POSTNETREV_SAVED_ALL593_TEXT_PROPS.ilist"))
  f=outfile(strcat(dir "/PUB403_NETREV_RESTORE_COMPLETE.txt")) fprintf(f "POSTNETREV_FULL2698_593POSE_TEXT_PROP_572LOGICAL_NAMES_EXACT_ORIGINAL_NO_AUTOSILK_ALLOWANCE_COMPLETE\nFRESH_GETCONNECT_COPPER_CFX_REQUIRED\n") close(f) count))
procedure(pub403RestoredFresh(dir)
 let((f)
  sstatus(fullPrecision t) pub403FullTypedGate(strcat(pub403Bundle "/TARGET_FULL2698_WITH_NONLOGICAL_IDENTITIES.ilist"))
  pub403StateGate(strcat(pub403Bundle "/SOURCE_CONTROL_EXPECTED_ALL593_TEXT_PROPS.ilist")) pub403AllNameGate(nil)
  pub403SnapshotAll(strcat(dir "/FRESH_ALL593_TEXT_PROPS.ilist")) pc13WriteMetadata(dir "restored_fresh")
  pub403Adjacency("target" dir)
  f=outfile(strcat(dir "/PUB403_RESTORED_FRESH_COMPLETE.txt")) fprintf(f "FRESH_FULL2698_593POSE_TEXT_PROP_572LOGICAL_NAMES_806TARGET_ADJ_EXACT_ORIGINAL_NO_AUTOSILK_ALLOWANCE_COMPLETE_NO_SAVE\nGETCONNECT915_COPPER_CFX_REQUIRED_SEPARATELY\n") close(f) t))
