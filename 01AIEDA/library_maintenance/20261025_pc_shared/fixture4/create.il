procedure(pc13Empty4(output report)
 let((f name x)
  unless(null(axlDBGetDesign()->symdefs) && null(axlDBGetDesign()->padstacks) error("Fixture is not empty"))
  foreach(name '("L2" "L3")
   unless(axlXSectionCreate(nil 'bottom axlXSectionModify(?name name ?layerType "CONDUCTOR" ?material "COPPER")) error("Fixture Cu create failed"))
   unless(axlXSectionCreate(nil 'bottom nil) error("Fixture dielectric create failed")))
  f=outfile(report)
  foreach(x axlXSectionGet(nil 'all) fprintf(f "%L\t%L\n" x->name x->layerType))
  fprintf(f "SYMBOLS=%L\nPADSTACKS=%L\n" axlDBGetDesign()->symdefs axlDBGetDesign()->padstacks) close(f)
  unless(axlSaveDesign(?design output ?noMru t ?noConfirm t) error("Fixture save failed"))
  t))
