procedure(deCustomCreate()
let((pad result style bound f)
unless(equal(axlDesignType(t) "PACKAGE") error("Not a package\n"))
unless(length(axlDBGetDesign()->pins)==0 error("Not empty\n"))
axlDBChangeDesignUnits("millimeters" 3)
axlDBChangeDesignExtents(list(-15:-15 15:15))
axlSetVariable("psmpath" list("D:/001DIY/005lib/01AIEDA/learning/examples/de_15_26_20261019/library"))
axlSetVariable("padpath" list("D:/001DIY/005lib/01AIEDA/learning/examples/de_15_26_20261019/library"))
style=make_axlTextOrientation(?textBlock "1" ?rotation 0 ?mirrored nil ?justify "center")
pad=axlLoadPadstack("VIA_1D0_1D54S")
unless(pad error("Cannot load pad\n"))
result=axlDBCreatePin(pad -1.25:0 make_axlPinText(?number "1" ?offset 0:0 ?text style) 0.0)
unless(result error("Cannot create pin\n"))
pad=axlLoadPadstack("VIA_1D0_1D54")
unless(pad error("Cannot load pad\n"))
result=axlDBCreatePin(pad 1.25:0 make_axlPinText(?number "2" ?offset 0:0 ?text style) 0.0)
unless(result error("Cannot create pin\n"))
unless(axlDBCreateLine(list(-3.15:-3.15 3.15:-3.15 3.15:3.15 -3.15:3.15 -3.15:-3.15) 0.05 "PACKAGE GEOMETRY/ASSEMBLY_TOP" nil nil) error("Assembly failed\n"))
result=axlDBCreateRectangle(list(-3.5:-3.5 3.5:3.5) t "PACKAGE GEOMETRY/PLACE_BOUND_TOP" nil nil)
unless(result error("Bound failed\n"))
bound=car(result)
unless(axlDBAddProp(list(bound) list("PACKAGE_HEIGHT_MAX" "11 MM")) error("Height failed\n"))
unless(axlDBCreateText("+" -2.7:0 style "PACKAGE GEOMETRY/SILKSCREEN_TOP" nil) error("Plus marker failed\n"))
unless(axlDBCreateText("X*" 0:0 style "REF DES/ASSEMBLY_TOP" nil) error("Refdes failed\n"))
unless(axlSaveDesign(?design "D:/001DIY/005lib/01AIEDA/learning/examples/de_15_26_20261019/library/de_capradial_6d3_p2d5.dra" ?noMru t ?noConfirm t) error("Save failed\n"))
unless(axlCompileSymbol(?symbol "D:/001DIY/005lib/01AIEDA/learning/examples/de_15_26_20261019/library/de_capradial_6d3_p2d5") error("Compile failed\n"))
f=outfile("D:/001DIY/005lib/01AIEDA/learning/staging/de_15_26_20261019/create_de_capradial_6d3_p2d5/create.txt")
fprintf(f "DE_CUSTOM_CREATE_COMPLETE de_capradial_6d3_p2d5\n")
close(f)
t))
