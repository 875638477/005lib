; Apply user-defined library defaults to the isolated lesson04 package only.
procedure(edaPackageDefaultsApply(libDir reportPath)
  let((report layerName objects obj targetTexts textStyle textValue changed
       bounds boundRecord props saved compiled)
    report = outfile(reportPath)
    unless(report error("Cannot open defaults report\n"))
    fprintf(report "EDA_PACKAGE_DEFAULTS START\ndesign=%L units=%L\n" axlCurrentDesign() axlDBGetDesignUnits())
    unless(equal(axlCurrentDesign() "eda_l04_two_pin_training")
      error("Defaults update restricted to lesson04 package\n"))
    unless(equal(axlDBGetDesignUnits() list("millimeters" 3))
      error("Expected existing millimeter training drawing\n"))
    textStyle = make_axlTextOrientation(?textBlock "2" ?rotation 0.0 ?mirrored nil ?justify "center")
    foreach(layerName list("REF DES/SILKSCREEN_TOP" "REF DES/ASSEMBLY_TOP" "COMPONENT VALUE/ASSEMBLY_TOP")
      objects = axlExtractMap("C:/Program0/Cadence/SPB172/share/pcb/text/views/fgeo_bv.txt" nil)
      targetTexts = nil
      foreach(obj objects
        when(equal(obj->objType "text") && equal(obj->layer layerName)
          targetTexts = cons(obj targetTexts))
      )
      if(targetTexts then
        foreach(obj targetTexts
          changed = axlTransformObject(obj ?move list(-car(obj->xy) -cadr(obj->xy)))
          unless(changed error("Cannot move required text to origin\n"))
        )
        fprintf(report "text_layer=%L moved_existing=%d anchor=(0.0 0.0)\n" layerName length(targetTexts))
      else
        textValue = if(equal(layerName "COMPONENT VALUE/ASSEMBLY_TOP") then "VALUE" else "U*")
        changed = axlDBCreateText(textValue 0:0 textStyle layerName nil)
        unless(changed error("Cannot create text on %s\n" layerName))
        fprintf(report "text_layer=%L created=%L anchor=(0.0 0.0)\n" layerName textValue)
      )
    )
    bounds = axlDBGetShapes("PACKAGE GEOMETRY/PLACE_BOUND_TOP")
    unless(bounds error("No place bound for package height\n"))
    foreach(boundRecord bounds
      changed = axlDBAddProp(list(boundRecord) list("PACKAGE_HEIGHT_MAX" "1 MM"))
      unless(changed error("Cannot set package height\n"))
      props = axlDBGetProperties(boundRecord nil)
      fprintf(report "height_properties=%L\n" props)
    )
    saved = axlSaveDesign(?design strcat(libDir "/eda_l04_two_pin_training.dra") ?noMru t ?noConfirm t)
    unless(saved error("Cannot save updated package\n"))
    fprintf(report "saved=%L\n" saved)
    compiled = axlCompileSymbol(?symbol strcat(libDir "/eda_l04_two_pin_training"))
    unless(compiled error("Cannot compile updated package\n"))
    fprintf(report "compiled=%L\nEDA_PACKAGE_DEFAULTS COMPLETE\n" compiled)
    close(report)
    t
  )
)
procedure(edaPackageDefaultsRead(outDir)
  let((report textFile objects obj bounds boundRecord props)
    report = outfile(strcat(outDir "/defaults.txt"))
    textFile = outfile(strcat(outDir "/required_texts.tsv"))
    unless(report && textFile error("Cannot open defaults read-back outputs\n"))
    fprintf(report "EDA_PACKAGE_DEFAULTS_READ START\nunits=%L\n" axlDBGetDesignUnits())
    fprintf(textFile "layer\ttext\tx\ty\trotation\n")
    objects = axlExtractMap("C:/Program0/Cadence/SPB172/share/pcb/text/views/fgeo_bv.txt" nil)
    foreach(obj objects
      when(equal(obj->objType "text") && member(obj->layer list("REF DES/SILKSCREEN_TOP" "REF DES/ASSEMBLY_TOP" "COMPONENT VALUE/ASSEMBLY_TOP"))
        fprintf(textFile "%L\t%L\t%L\t%L\t%L\n" obj->layer obj->text car(obj->xy) cadr(obj->xy) obj->rotation))
    )
    bounds = axlDBGetShapes("PACKAGE GEOMETRY/PLACE_BOUND_TOP")
    fprintf(report "place_bound_count=%d\n" length(bounds))
    foreach(boundRecord bounds
      props = axlDBGetProperties(boundRecord nil)
      fprintf(report "bbox=%L properties=%L\n" boundRecord->bBox props))
    fprintf(report "EDA_PACKAGE_DEFAULTS_READ COMPLETE\n")
    close(textFile)
    close(report)
    t
  )
)
