procedure(deCustomCreate()
let((pad result style bound f)
unless(equal(axlDesignType(t) "PACKAGE") error("Not a package\n"))
unless(length(axlDBGetDesign()->pins)==0 error("Not empty\n"))
axlDBChangeDesignUnits("millimeters" 3)
axlDBChangeDesignExtents(list(-15:-15 15:15))
axlSetVariable("psmpath" list("D:/001DIY/005lib/01AIEDA/learning/examples/de_15_26_20261019/library"))
axlSetVariable("padpath" list("D:/001DIY/005lib/01AIEDA/learning/examples/de_15_26_20261019/library"))
style=make_axlTextOrientation(?textBlock "1" ?rotation 0 ?mirrored nil ?justify "center")
pad=axlLoadPadstack("de_smd143x550")
unless(pad error("Cannot load pad\n"))
result=axlDBCreatePin(pad 2.02:0 make_axlPinText(?number "1" ?offset 0:0 ?text style) 0.0)
unless(result error("Cannot create pin\n"))
pad=axlLoadPadstack("de_smd143x550")
unless(pad error("Cannot load pad\n"))
result=axlDBCreatePin(pad -2.02:0 make_axlPinText(?number "2" ?offset 0:0 ?text style) 0.0)
unless(result error("Cannot create pin\n"))
unless(axlDBCreateLine(list(-3.28:-3.38 3.28:-3.38 3.28:3.38 -3.28:3.38 -3.28:-3.38) 0.05 "PACKAGE GEOMETRY/ASSEMBLY_TOP" nil nil) error("Assembly failed\n"))
result=axlDBCreateRectangle(list(-3.55:-3.65 3.55:3.65) t "PACKAGE GEOMETRY/PLACE_BOUND_TOP" nil nil)
unless(result error("Bound failed\n"))
bound=car(result)
unless(axlDBAddProp(list(bound) list("PACKAGE_HEIGHT_MAX" "6.1 MM")) error("Height failed\n"))
unless(axlDBCreateLine(list(3.4:-2.6 3.4:2.6) 0.12 "PACKAGE GEOMETRY/SILKSCREEN_TOP" nil nil) error("Short lead marker failed\n"))
unless(axlDBCreateText("X*" 0:0 style "REF DES/ASSEMBLY_TOP" nil) error("Refdes failed\n"))
unless(axlSaveDesign(?design "D:/001DIY/005lib/01AIEDA/learning/examples/de_15_26_20261019/library/de_xal6060_2land.dra" ?noMru t ?noConfirm t) error("Save failed\n"))
unless(axlCompileSymbol(?symbol "D:/001DIY/005lib/01AIEDA/learning/examples/de_15_26_20261019/library/de_xal6060_2land") error("Compile failed\n"))
f=outfile("D:/001DIY/005lib/01AIEDA/learning/staging/de_15_26_20261019/create_de_xal6060_2land/create.txt")
fprintf(f "DE_CUSTOM_CREATE_COMPLETE de_xal6060_2land\n")
close(f)
t))
