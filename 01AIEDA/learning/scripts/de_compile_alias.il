procedure(deCompileAlias(lib)
 let((name)
  name=axlCurrentDesign()
  axlSetVariable("psmpath" list(lib))
  axlSetVariable("padpath" list(lib))
  unless(axlSaveDesign(?design strcat(lib "/" name ".dra") ?noMru t ?noConfirm t) error("Alias save failed\n"))
  unless(axlCompileSymbol(?symbol strcat(lib "/" name)) error("Alias compile failed\n"))
  printf("DE_ALIAS_COMPLETE %s\n" name)
  t))
