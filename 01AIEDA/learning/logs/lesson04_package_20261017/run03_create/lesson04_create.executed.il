; Lesson04: creates only the new, isolated training package supplied on CLI.
procedure(edaL4Create(libDir reportPath)
  let((report units padRecord textStyle pinText result saved compiled)
    report = outfile(reportPath)
    unless(report error("Cannot open lesson04 create report\n"))
    fprintf(report "EDA_LESSON04_CREATE START\ndesign=%L type=%L\n" axlCurrentDesign() axlDesignType(t))
    unless(equal(axlDesignType(t) "PACKAGE") || equal(axlDesignType(t) "package")
      error("Creation requires a new package symbol drawing\n"))
    unless(length(axlDBGetDesign()->pins) == 0
      error("Creation requires an empty training drawing\n"))
    axlDBChangeDesignUnits("millimeters" 3)
    units = axlDBGetDesignUnits()
    fprintf(report "units=%L\n" units)
    unless(equal(units list("millimeters" 3)) error("Unexpected design units\n"))
    unless(axlDBChangeDesignExtents(list(-10.0:-10.0 10.0:10.0))
      error("Cannot set symmetric training drawing extents\n"))
    fprintf(report "drawing_extents_requested=((-10.0 -10.0) (10.0 10.0))\n")
    axlSetVariable("padpath" list(libDir))
    axlSetVariable("psmpath" list(libDir))
    fprintf(report "padpath=%L\n" axlGetVariableList("padpath"))
    padRecord = axlLoadPadstack("eda_l04_smd_1000x1500")
    unless(padRecord error("Cannot load lesson04 padstack\n"))
    textStyle = make_axlTextOrientation(?textBlock "2" ?rotation 0.0 ?mirrored nil ?justify "center")
    pinText = make_axlPinText(?number "1" ?offset 0:0 ?text textStyle)
    result = axlDBCreatePin(padRecord -1.0:0.0 pinText 0.0)
    unless(result error("Cannot create pin 1\n"))
    fprintf(report "created_pin1=%L drc_created=%L\n" car(result)->number cadr(result))
    pinText = make_axlPinText(?number "2" ?offset 0:0 ?text textStyle)
    result = axlDBCreatePin(padRecord 1.0:0.0 pinText 0.0)
    unless(result error("Cannot create pin 2\n"))
    fprintf(report "created_pin2=%L drc_created=%L\n" car(result)->number cadr(result))
    result = axlDBCreateLine(list(-1.7:-1.0 1.7:-1.0 1.7:1.0 -1.7:1.0 -1.7:-1.0)
      0.1 "PACKAGE GEOMETRY/SILKSCREEN_TOP" nil nil)
    unless(result error("Cannot create silkscreen outline\n"))
    fprintf(report "silkscreen_created=%L drc_created=%L\n" car(result) cadr(result))
    result = axlDBCreateLine(list(-0.8:-0.5 0.8:-0.5 0.8:0.5 -0.8:0.5 -0.8:-0.5)
      0.05 "PACKAGE GEOMETRY/ASSEMBLY_TOP" nil nil)
    unless(result error("Cannot create assembly outline\n"))
    fprintf(report "assembly_created=%L drc_created=%L\n" car(result) cadr(result))
    result = axlDBCreateRectangle(list(-1.8:-1.1 1.8:1.1) t "PACKAGE GEOMETRY/PLACE_BOUND_TOP" nil nil)
    unless(result error("Cannot create filled place bound\n"))
    fprintf(report "place_bound_created=%L drc_created=%L\n" car(result) cadr(result))
    result = axlDBCreateText("REF**" 0:1.6 textStyle "REF DES/SILKSCREEN_TOP" nil)
    unless(result error("Cannot create reference designator placeholder\n"))
    fprintf(report "refdes_created=%L drc_created=%L\n" car(result) cadr(result))
    saved = axlSaveDesign(?design strcat(libDir "/eda_l04_two_pin_training.dra") ?noMru t ?noConfirm t)
    fprintf(report "saved=%L\n" saved)
    unless(saved error("Cannot save training drawing\n"))
    ; Saving invalidates dbids: reacquire everything for the next operation.
    fprintf(report "pins_after_save=%d\n" length(axlDBGetDesign()->pins))
    compiled = axlCompileSymbol(?symbol strcat(libDir "/eda_l04_two_pin_training"))
    fprintf(report "compiled=%L\n" compiled)
    unless(compiled error("Cannot compile training package\n"))
    fprintf(report "EDA_LESSON04_CREATE COMPLETE\n")
    close(report)
    t
  )
)
