procedure(lgaPackageRead(out)
 let((f p layer pad box)
  f=outfile(strcat(out "/pins.tsv"))
  unless(f error("Cannot write package report\n"))
  fprintf(f "pin\tpadstack\tx\ty\tmechanical\tlayer\tfigure\tw\th\tdrill\tplating\n")
  foreach(p axlDBGetDesign()->pins
   foreach(layer list("ETCH/TOP" "ETCH/BOTTOM" "PIN/SOLDERMASK_TOP" "PIN/PASTEMASK_TOP")
    pad=axlDBGetPad(p layer "REGULAR")
    box=if(pad then pad->bBox else nil)
    fprintf(f "%L\t%L\t%L\t%L\t%L\t%s\t%L\t%L\t%L\t%L\t%L\n"
     p->number p->name car(p->xy) cadr(p->xy) p->isMech layer if(pad then pad->figureName else nil)
     if(box then car(cadr(box))-car(car(box)) else nil)
     if(box then cadr(cadr(box))-cadr(car(box)) else nil)
     if(p->definition then p->definition->drillDiameter else nil)
     if(p->definition then p->definition->plating else nil))))
  close(f)
  f=outfile(strcat(out "/summary.txt"))
  fprintf(f "PACKAGE_READ_COMPLETE\nname=%s\nunits=%L\npins=%d\n" axlCurrentDesign() axlDBGetDesignUnits() length(axlDBGetDesign()->pins))
  close(f)
  t))
