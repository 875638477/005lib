procedure(lgaCompileResistorAlias(lib pads)
 let((name)
  name=axlCurrentDesign()
  unless(equal(name "r0402_pp_2") error("Unexpected alias input name\n"))
  axlSetVariable("psmpath" list(lib))
  axlSetVariable("padpath" list(pads))
  unless(axlSaveDesign(?design strcat(lib "/r0402_pp_2.dra") ?noMru t ?noConfirm t) error("Alias save failed\n"))
  unless(axlCompileSymbol(?symbol strcat(lib "/r0402_pp_2")) error("Alias compilation failed\n"))
  printf("LGA_ALIAS_COMPLETE %s\n" name)
  t))
