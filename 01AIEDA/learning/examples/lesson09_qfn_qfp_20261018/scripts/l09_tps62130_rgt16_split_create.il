procedure(l9Create_l09_tps62130_rgt16_split()
let((f pad style ns result bound windows)
unless(equal(axlCurrentDesign() "l09_tps62130_rgt16_split") error("Wrong drawing\n"))
unless(length(axlDBGetDesign()->pins)==0 error("Not empty\n"))
axlDBChangeDesignUnits("millimeters" 3)
axlDBChangeDesignExtents(list(-12:-12 12:12))
axlSetVariable("padpath" list("D:/001DIY/005lib/01AIEDA/learning/examples/lesson09_qfn_qfp_20261018/library"))
axlSetVariable("psmpath" list("D:/001DIY/005lib/01AIEDA/learning/examples/lesson09_qfn_qfp_20261018/library"))
f=outfile("D:/001DIY/005lib/01AIEDA/learning/examples/lesson09_qfn_qfp_20261018/logs/l09_tps62130_rgt16_split_create/create.txt")
style=make_axlTextOrientation(?textBlock "2" ?rotation 0 ?mirrored nil ?justify "center")
ns=make_axlTextOrientation(?textBlock "1" ?rotation 0 ?mirrored nil ?justify "center")
pad=axlLoadPadstack("l09_qfn060x024_r005_m07")
unless(pad error("Pad load failed\n"))
result=axlDBCreatePin(pad -1.400:0.750 make_axlPinText(?number "1" ?offset 0:0 ?text ns) 0)
unless(result error("Pin create failed\n"))
pad=axlLoadPadstack("l09_qfn060x024_r005_m07")
unless(pad error("Pad load failed\n"))
result=axlDBCreatePin(pad -1.400:0.250 make_axlPinText(?number "2" ?offset 0:0 ?text ns) 0)
unless(result error("Pin create failed\n"))
pad=axlLoadPadstack("l09_qfn060x024_r005_m07")
unless(pad error("Pad load failed\n"))
result=axlDBCreatePin(pad -1.400:-0.250 make_axlPinText(?number "3" ?offset 0:0 ?text ns) 0)
unless(result error("Pin create failed\n"))
pad=axlLoadPadstack("l09_qfn060x024_r005_m07")
unless(pad error("Pad load failed\n"))
result=axlDBCreatePin(pad -1.400:-0.750 make_axlPinText(?number "4" ?offset 0:0 ?text ns) 0)
unless(result error("Pin create failed\n"))
pad=axlLoadPadstack("l09_qfn060x024_r005_m07")
unless(pad error("Pad load failed\n"))
result=axlDBCreatePin(pad -0.750:-1.400 make_axlPinText(?number "5" ?offset 0:0 ?text ns) 90)
unless(result error("Pin create failed\n"))
pad=axlLoadPadstack("l09_qfn060x024_r005_m07")
unless(pad error("Pad load failed\n"))
result=axlDBCreatePin(pad -0.250:-1.400 make_axlPinText(?number "6" ?offset 0:0 ?text ns) 90)
unless(result error("Pin create failed\n"))
pad=axlLoadPadstack("l09_qfn060x024_r005_m07")
unless(pad error("Pad load failed\n"))
result=axlDBCreatePin(pad 0.250:-1.400 make_axlPinText(?number "7" ?offset 0:0 ?text ns) 90)
unless(result error("Pin create failed\n"))
pad=axlLoadPadstack("l09_qfn060x024_r005_m07")
unless(pad error("Pad load failed\n"))
result=axlDBCreatePin(pad 0.750:-1.400 make_axlPinText(?number "8" ?offset 0:0 ?text ns) 90)
unless(result error("Pin create failed\n"))
pad=axlLoadPadstack("l09_qfn060x024_r005_m07")
unless(pad error("Pad load failed\n"))
result=axlDBCreatePin(pad 1.400:-0.750 make_axlPinText(?number "9" ?offset 0:0 ?text ns) 0)
unless(result error("Pin create failed\n"))
pad=axlLoadPadstack("l09_qfn060x024_r005_m07")
unless(pad error("Pad load failed\n"))
result=axlDBCreatePin(pad 1.400:-0.250 make_axlPinText(?number "10" ?offset 0:0 ?text ns) 0)
unless(result error("Pin create failed\n"))
pad=axlLoadPadstack("l09_qfn060x024_r005_m07")
unless(pad error("Pad load failed\n"))
result=axlDBCreatePin(pad 1.400:0.250 make_axlPinText(?number "11" ?offset 0:0 ?text ns) 0)
unless(result error("Pin create failed\n"))
pad=axlLoadPadstack("l09_qfn060x024_r005_m07")
unless(pad error("Pad load failed\n"))
result=axlDBCreatePin(pad 1.400:0.750 make_axlPinText(?number "12" ?offset 0:0 ?text ns) 0)
unless(result error("Pin create failed\n"))
pad=axlLoadPadstack("l09_qfn060x024_r005_m07")
unless(pad error("Pad load failed\n"))
result=axlDBCreatePin(pad 0.750:1.400 make_axlPinText(?number "13" ?offset 0:0 ?text ns) 90)
unless(result error("Pin create failed\n"))
pad=axlLoadPadstack("l09_qfn060x024_r005_m07")
unless(pad error("Pad load failed\n"))
result=axlDBCreatePin(pad 0.250:1.400 make_axlPinText(?number "14" ?offset 0:0 ?text ns) 90)
unless(result error("Pin create failed\n"))
pad=axlLoadPadstack("l09_qfn060x024_r005_m07")
unless(pad error("Pad load failed\n"))
result=axlDBCreatePin(pad -0.250:1.400 make_axlPinText(?number "15" ?offset 0:0 ?text ns) 90)
unless(result error("Pin create failed\n"))
pad=axlLoadPadstack("l09_qfn060x024_r005_m07")
unless(pad error("Pad load failed\n"))
result=axlDBCreatePin(pad -0.750:1.400 make_axlPinText(?number "16" ?offset 0:0 ?text ns) 90)
unless(result error("Pin create failed\n"))
pad=axlLoadPadstack("l09_ep168_m07_nopaste")
unless(pad error("Pad load failed\n"))
result=axlDBCreatePin(pad 0.000:0.000 make_axlPinText(?number "17" ?offset 0:0 ?text ns) 0)
unless(result error("Pin create failed\n"))
unless(axlDBCreateLine(list(-1.55:-1.55 1.55:-1.55 1.55:1.55 -1.55:1.55 -1.55:-1.55) 0.05 "PACKAGE GEOMETRY/ASSEMBLY_TOP" nil nil) error("Assembly failed\n"))
unless(axlDBCreateLine(list(-1.650:-1.950 -1.950:-1.950 -1.950:-1.650) 0.1 "PACKAGE GEOMETRY/SILKSCREEN_TOP" nil nil) error("Silk failed\n"))
unless(axlDBCreateLine(list(-1.650:1.950 -1.950:1.950 -1.950:1.650) 0.1 "PACKAGE GEOMETRY/SILKSCREEN_TOP" nil nil) error("Silk failed\n"))
unless(axlDBCreateLine(list(1.650:-1.950 1.950:-1.950 1.950:-1.650) 0.1 "PACKAGE GEOMETRY/SILKSCREEN_TOP" nil nil) error("Silk failed\n"))
unless(axlDBCreateLine(list(1.650:1.950 1.950:1.950 1.950:1.650) 0.1 "PACKAGE GEOMETRY/SILKSCREEN_TOP" nil nil) error("Silk failed\n"))
unless(axlDBCreateLine(list(-1.8199999999999998:1.8199999999999998 -1.7199999999999998:1.8199999999999998 -1.8199999999999998:1.7199999999999998 -1.8199999999999998:1.8199999999999998) 0.05 "PACKAGE GEOMETRY/SILKSCREEN_TOP" nil nil) error("Marker failed\n"))
result=axlDBCreateRectangle(list(-1.95:-1.95 1.95:1.95) t "PACKAGE GEOMETRY/PLACE_BOUND_TOP" nil nil)
unless(result error("Bound failed\n"))
bound=car(result)
unless(axlDBAddProp(list(bound) list("PACKAGE_HEIGHT_MAX" "1 MM")) error("Height failed\n"))
unless(axlDBCreateRectangle(list(-0.750:-0.750 -0.100:-0.100) t "PACKAGE GEOMETRY/PASTEMASK_TOP" nil nil) error("Paste window failed\n"))
unless(axlDBCreateRectangle(list(-0.750:0.100 -0.100:0.750) t "PACKAGE GEOMETRY/PASTEMASK_TOP" nil nil) error("Paste window failed\n"))
unless(axlDBCreateRectangle(list(0.100:-0.750 0.750:-0.100) t "PACKAGE GEOMETRY/PASTEMASK_TOP" nil nil) error("Paste window failed\n"))
unless(axlDBCreateRectangle(list(0.100:0.100 0.750:0.750) t "PACKAGE GEOMETRY/PASTEMASK_TOP" nil nil) error("Paste window failed\n"))
unless(axlDBCreateText("U*" 0:0 style "REF DES/SILKSCREEN_TOP" nil) error("Text failed\n"))
unless(axlDBCreateText("U*" 0:0 style "REF DES/ASSEMBLY_TOP" nil) error("Text failed\n"))
unless(axlDBCreateText("VALUE" 0:0 style "COMPONENT VALUE/ASSEMBLY_TOP" nil) error("Text failed\n"))
unless(axlSaveDesign(?design "D:/001DIY/005lib/01AIEDA/learning/examples/lesson09_qfn_qfp_20261018/library/l09_tps62130_rgt16_split.dra" ?noMru t ?noConfirm t) error("Save failed\n"))
unless(axlCompileSymbol(?symbol "D:/001DIY/005lib/01AIEDA/learning/examples/lesson09_qfn_qfp_20261018/library/l09_tps62130_rgt16_split") error("Compile failed\n"))
fprintf(f "L09 CREATE COMPLETE\n")
close(f)
t))
