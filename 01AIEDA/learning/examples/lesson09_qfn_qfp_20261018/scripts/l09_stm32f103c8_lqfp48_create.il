procedure(l9Create_l09_stm32f103c8_lqfp48()
let((f pad style ns result bound windows)
unless(equal(axlCurrentDesign() "l09_stm32f103c8_lqfp48") error("Wrong drawing\n"))
unless(length(axlDBGetDesign()->pins)==0 error("Not empty\n"))
axlDBChangeDesignUnits("millimeters" 3)
axlDBChangeDesignExtents(list(-12:-12 12:12))
axlSetVariable("padpath" list("D:/001DIY/005lib/01AIEDA/learning/examples/lesson09_qfn_qfp_20261018/library"))
axlSetVariable("psmpath" list("D:/001DIY/005lib/01AIEDA/learning/examples/lesson09_qfn_qfp_20261018/library"))
f=outfile("D:/001DIY/005lib/01AIEDA/learning/examples/lesson09_qfn_qfp_20261018/logs/l09_stm32f103c8_lqfp48_create/create.txt")
style=make_axlTextOrientation(?textBlock "2" ?rotation 0 ?mirrored nil ?justify "center")
ns=make_axlTextOrientation(?textBlock "1" ?rotation 0 ?mirrored nil ?justify "center")
pad=axlLoadPadstack("l09_qfp120x030_m05")
unless(pad error("Pad load failed\n"))
result=axlDBCreatePin(pad -4.250:2.750 make_axlPinText(?number "1" ?offset 0:0 ?text ns) 0)
unless(result error("Pin create failed\n"))
pad=axlLoadPadstack("l09_qfp120x030_m05")
unless(pad error("Pad load failed\n"))
result=axlDBCreatePin(pad -4.250:2.250 make_axlPinText(?number "2" ?offset 0:0 ?text ns) 0)
unless(result error("Pin create failed\n"))
pad=axlLoadPadstack("l09_qfp120x030_m05")
unless(pad error("Pad load failed\n"))
result=axlDBCreatePin(pad -4.250:1.750 make_axlPinText(?number "3" ?offset 0:0 ?text ns) 0)
unless(result error("Pin create failed\n"))
pad=axlLoadPadstack("l09_qfp120x030_m05")
unless(pad error("Pad load failed\n"))
result=axlDBCreatePin(pad -4.250:1.250 make_axlPinText(?number "4" ?offset 0:0 ?text ns) 0)
unless(result error("Pin create failed\n"))
pad=axlLoadPadstack("l09_qfp120x030_m05")
unless(pad error("Pad load failed\n"))
result=axlDBCreatePin(pad -4.250:0.750 make_axlPinText(?number "5" ?offset 0:0 ?text ns) 0)
unless(result error("Pin create failed\n"))
pad=axlLoadPadstack("l09_qfp120x030_m05")
unless(pad error("Pad load failed\n"))
result=axlDBCreatePin(pad -4.250:0.250 make_axlPinText(?number "6" ?offset 0:0 ?text ns) 0)
unless(result error("Pin create failed\n"))
pad=axlLoadPadstack("l09_qfp120x030_m05")
unless(pad error("Pad load failed\n"))
result=axlDBCreatePin(pad -4.250:-0.250 make_axlPinText(?number "7" ?offset 0:0 ?text ns) 0)
unless(result error("Pin create failed\n"))
pad=axlLoadPadstack("l09_qfp120x030_m05")
unless(pad error("Pad load failed\n"))
result=axlDBCreatePin(pad -4.250:-0.750 make_axlPinText(?number "8" ?offset 0:0 ?text ns) 0)
unless(result error("Pin create failed\n"))
pad=axlLoadPadstack("l09_qfp120x030_m05")
unless(pad error("Pad load failed\n"))
result=axlDBCreatePin(pad -4.250:-1.250 make_axlPinText(?number "9" ?offset 0:0 ?text ns) 0)
unless(result error("Pin create failed\n"))
pad=axlLoadPadstack("l09_qfp120x030_m05")
unless(pad error("Pad load failed\n"))
result=axlDBCreatePin(pad -4.250:-1.750 make_axlPinText(?number "10" ?offset 0:0 ?text ns) 0)
unless(result error("Pin create failed\n"))
pad=axlLoadPadstack("l09_qfp120x030_m05")
unless(pad error("Pad load failed\n"))
result=axlDBCreatePin(pad -4.250:-2.250 make_axlPinText(?number "11" ?offset 0:0 ?text ns) 0)
unless(result error("Pin create failed\n"))
pad=axlLoadPadstack("l09_qfp120x030_m05")
unless(pad error("Pad load failed\n"))
result=axlDBCreatePin(pad -4.250:-2.750 make_axlPinText(?number "12" ?offset 0:0 ?text ns) 0)
unless(result error("Pin create failed\n"))
pad=axlLoadPadstack("l09_qfp120x030_m05")
unless(pad error("Pad load failed\n"))
result=axlDBCreatePin(pad -2.750:-4.250 make_axlPinText(?number "13" ?offset 0:0 ?text ns) 90)
unless(result error("Pin create failed\n"))
pad=axlLoadPadstack("l09_qfp120x030_m05")
unless(pad error("Pad load failed\n"))
result=axlDBCreatePin(pad -2.250:-4.250 make_axlPinText(?number "14" ?offset 0:0 ?text ns) 90)
unless(result error("Pin create failed\n"))
pad=axlLoadPadstack("l09_qfp120x030_m05")
unless(pad error("Pad load failed\n"))
result=axlDBCreatePin(pad -1.750:-4.250 make_axlPinText(?number "15" ?offset 0:0 ?text ns) 90)
unless(result error("Pin create failed\n"))
pad=axlLoadPadstack("l09_qfp120x030_m05")
unless(pad error("Pad load failed\n"))
result=axlDBCreatePin(pad -1.250:-4.250 make_axlPinText(?number "16" ?offset 0:0 ?text ns) 90)
unless(result error("Pin create failed\n"))
pad=axlLoadPadstack("l09_qfp120x030_m05")
unless(pad error("Pad load failed\n"))
result=axlDBCreatePin(pad -0.750:-4.250 make_axlPinText(?number "17" ?offset 0:0 ?text ns) 90)
unless(result error("Pin create failed\n"))
pad=axlLoadPadstack("l09_qfp120x030_m05")
unless(pad error("Pad load failed\n"))
result=axlDBCreatePin(pad -0.250:-4.250 make_axlPinText(?number "18" ?offset 0:0 ?text ns) 90)
unless(result error("Pin create failed\n"))
pad=axlLoadPadstack("l09_qfp120x030_m05")
unless(pad error("Pad load failed\n"))
result=axlDBCreatePin(pad 0.250:-4.250 make_axlPinText(?number "19" ?offset 0:0 ?text ns) 90)
unless(result error("Pin create failed\n"))
pad=axlLoadPadstack("l09_qfp120x030_m05")
unless(pad error("Pad load failed\n"))
result=axlDBCreatePin(pad 0.750:-4.250 make_axlPinText(?number "20" ?offset 0:0 ?text ns) 90)
unless(result error("Pin create failed\n"))
pad=axlLoadPadstack("l09_qfp120x030_m05")
unless(pad error("Pad load failed\n"))
result=axlDBCreatePin(pad 1.250:-4.250 make_axlPinText(?number "21" ?offset 0:0 ?text ns) 90)
unless(result error("Pin create failed\n"))
pad=axlLoadPadstack("l09_qfp120x030_m05")
unless(pad error("Pad load failed\n"))
result=axlDBCreatePin(pad 1.750:-4.250 make_axlPinText(?number "22" ?offset 0:0 ?text ns) 90)
unless(result error("Pin create failed\n"))
pad=axlLoadPadstack("l09_qfp120x030_m05")
unless(pad error("Pad load failed\n"))
result=axlDBCreatePin(pad 2.250:-4.250 make_axlPinText(?number "23" ?offset 0:0 ?text ns) 90)
unless(result error("Pin create failed\n"))
pad=axlLoadPadstack("l09_qfp120x030_m05")
unless(pad error("Pad load failed\n"))
result=axlDBCreatePin(pad 2.750:-4.250 make_axlPinText(?number "24" ?offset 0:0 ?text ns) 90)
unless(result error("Pin create failed\n"))
pad=axlLoadPadstack("l09_qfp120x030_m05")
unless(pad error("Pad load failed\n"))
result=axlDBCreatePin(pad 4.250:-2.750 make_axlPinText(?number "25" ?offset 0:0 ?text ns) 0)
unless(result error("Pin create failed\n"))
pad=axlLoadPadstack("l09_qfp120x030_m05")
unless(pad error("Pad load failed\n"))
result=axlDBCreatePin(pad 4.250:-2.250 make_axlPinText(?number "26" ?offset 0:0 ?text ns) 0)
unless(result error("Pin create failed\n"))
pad=axlLoadPadstack("l09_qfp120x030_m05")
unless(pad error("Pad load failed\n"))
result=axlDBCreatePin(pad 4.250:-1.750 make_axlPinText(?number "27" ?offset 0:0 ?text ns) 0)
unless(result error("Pin create failed\n"))
pad=axlLoadPadstack("l09_qfp120x030_m05")
unless(pad error("Pad load failed\n"))
result=axlDBCreatePin(pad 4.250:-1.250 make_axlPinText(?number "28" ?offset 0:0 ?text ns) 0)
unless(result error("Pin create failed\n"))
pad=axlLoadPadstack("l09_qfp120x030_m05")
unless(pad error("Pad load failed\n"))
result=axlDBCreatePin(pad 4.250:-0.750 make_axlPinText(?number "29" ?offset 0:0 ?text ns) 0)
unless(result error("Pin create failed\n"))
pad=axlLoadPadstack("l09_qfp120x030_m05")
unless(pad error("Pad load failed\n"))
result=axlDBCreatePin(pad 4.250:-0.250 make_axlPinText(?number "30" ?offset 0:0 ?text ns) 0)
unless(result error("Pin create failed\n"))
pad=axlLoadPadstack("l09_qfp120x030_m05")
unless(pad error("Pad load failed\n"))
result=axlDBCreatePin(pad 4.250:0.250 make_axlPinText(?number "31" ?offset 0:0 ?text ns) 0)
unless(result error("Pin create failed\n"))
pad=axlLoadPadstack("l09_qfp120x030_m05")
unless(pad error("Pad load failed\n"))
result=axlDBCreatePin(pad 4.250:0.750 make_axlPinText(?number "32" ?offset 0:0 ?text ns) 0)
unless(result error("Pin create failed\n"))
pad=axlLoadPadstack("l09_qfp120x030_m05")
unless(pad error("Pad load failed\n"))
result=axlDBCreatePin(pad 4.250:1.250 make_axlPinText(?number "33" ?offset 0:0 ?text ns) 0)
unless(result error("Pin create failed\n"))
pad=axlLoadPadstack("l09_qfp120x030_m05")
unless(pad error("Pad load failed\n"))
result=axlDBCreatePin(pad 4.250:1.750 make_axlPinText(?number "34" ?offset 0:0 ?text ns) 0)
unless(result error("Pin create failed\n"))
pad=axlLoadPadstack("l09_qfp120x030_m05")
unless(pad error("Pad load failed\n"))
result=axlDBCreatePin(pad 4.250:2.250 make_axlPinText(?number "35" ?offset 0:0 ?text ns) 0)
unless(result error("Pin create failed\n"))
pad=axlLoadPadstack("l09_qfp120x030_m05")
unless(pad error("Pad load failed\n"))
result=axlDBCreatePin(pad 4.250:2.750 make_axlPinText(?number "36" ?offset 0:0 ?text ns) 0)
unless(result error("Pin create failed\n"))
pad=axlLoadPadstack("l09_qfp120x030_m05")
unless(pad error("Pad load failed\n"))
result=axlDBCreatePin(pad 2.750:4.250 make_axlPinText(?number "37" ?offset 0:0 ?text ns) 90)
unless(result error("Pin create failed\n"))
pad=axlLoadPadstack("l09_qfp120x030_m05")
unless(pad error("Pad load failed\n"))
result=axlDBCreatePin(pad 2.250:4.250 make_axlPinText(?number "38" ?offset 0:0 ?text ns) 90)
unless(result error("Pin create failed\n"))
pad=axlLoadPadstack("l09_qfp120x030_m05")
unless(pad error("Pad load failed\n"))
result=axlDBCreatePin(pad 1.750:4.250 make_axlPinText(?number "39" ?offset 0:0 ?text ns) 90)
unless(result error("Pin create failed\n"))
pad=axlLoadPadstack("l09_qfp120x030_m05")
unless(pad error("Pad load failed\n"))
result=axlDBCreatePin(pad 1.250:4.250 make_axlPinText(?number "40" ?offset 0:0 ?text ns) 90)
unless(result error("Pin create failed\n"))
pad=axlLoadPadstack("l09_qfp120x030_m05")
unless(pad error("Pad load failed\n"))
result=axlDBCreatePin(pad 0.750:4.250 make_axlPinText(?number "41" ?offset 0:0 ?text ns) 90)
unless(result error("Pin create failed\n"))
pad=axlLoadPadstack("l09_qfp120x030_m05")
unless(pad error("Pad load failed\n"))
result=axlDBCreatePin(pad 0.250:4.250 make_axlPinText(?number "42" ?offset 0:0 ?text ns) 90)
unless(result error("Pin create failed\n"))
pad=axlLoadPadstack("l09_qfp120x030_m05")
unless(pad error("Pad load failed\n"))
result=axlDBCreatePin(pad -0.250:4.250 make_axlPinText(?number "43" ?offset 0:0 ?text ns) 90)
unless(result error("Pin create failed\n"))
pad=axlLoadPadstack("l09_qfp120x030_m05")
unless(pad error("Pad load failed\n"))
result=axlDBCreatePin(pad -0.750:4.250 make_axlPinText(?number "44" ?offset 0:0 ?text ns) 90)
unless(result error("Pin create failed\n"))
pad=axlLoadPadstack("l09_qfp120x030_m05")
unless(pad error("Pad load failed\n"))
result=axlDBCreatePin(pad -1.250:4.250 make_axlPinText(?number "45" ?offset 0:0 ?text ns) 90)
unless(result error("Pin create failed\n"))
pad=axlLoadPadstack("l09_qfp120x030_m05")
unless(pad error("Pad load failed\n"))
result=axlDBCreatePin(pad -1.750:4.250 make_axlPinText(?number "46" ?offset 0:0 ?text ns) 90)
unless(result error("Pin create failed\n"))
pad=axlLoadPadstack("l09_qfp120x030_m05")
unless(pad error("Pad load failed\n"))
result=axlDBCreatePin(pad -2.250:4.250 make_axlPinText(?number "47" ?offset 0:0 ?text ns) 90)
unless(result error("Pin create failed\n"))
pad=axlLoadPadstack("l09_qfp120x030_m05")
unless(pad error("Pad load failed\n"))
result=axlDBCreatePin(pad -2.750:4.250 make_axlPinText(?number "48" ?offset 0:0 ?text ns) 90)
unless(result error("Pin create failed\n"))
unless(axlDBCreateLine(list(-3.5:-3.5 3.5:-3.5 3.5:3.5 -3.5:3.5 -3.5:-3.5) 0.05 "PACKAGE GEOMETRY/ASSEMBLY_TOP" nil nil) error("Assembly failed\n"))
unless(axlDBCreateLine(list(-4.800:-5.100 -5.100:-5.100 -5.100:-4.800) 0.1 "PACKAGE GEOMETRY/SILKSCREEN_TOP" nil nil) error("Silk failed\n"))
unless(axlDBCreateLine(list(-4.800:5.100 -5.100:5.100 -5.100:4.800) 0.1 "PACKAGE GEOMETRY/SILKSCREEN_TOP" nil nil) error("Silk failed\n"))
unless(axlDBCreateLine(list(4.800:-5.100 5.100:-5.100 5.100:-4.800) 0.1 "PACKAGE GEOMETRY/SILKSCREEN_TOP" nil nil) error("Silk failed\n"))
unless(axlDBCreateLine(list(4.800:5.100 5.100:5.100 5.100:4.800) 0.1 "PACKAGE GEOMETRY/SILKSCREEN_TOP" nil nil) error("Silk failed\n"))
unless(axlDBCreateLine(list(-4.97:4.97 -4.87:4.97 -4.97:4.87 -4.97:4.97) 0.05 "PACKAGE GEOMETRY/SILKSCREEN_TOP" nil nil) error("Marker failed\n"))
result=axlDBCreateRectangle(list(-5.1:-5.1 5.1:5.1) t "PACKAGE GEOMETRY/PLACE_BOUND_TOP" nil nil)
unless(result error("Bound failed\n"))
bound=car(result)
unless(axlDBAddProp(list(bound) list("PACKAGE_HEIGHT_MAX" "1.6 MM")) error("Height failed\n"))
unless(axlDBCreateText("U*" 0:0 style "REF DES/SILKSCREEN_TOP" nil) error("Text failed\n"))
unless(axlDBCreateText("U*" 0:0 style "REF DES/ASSEMBLY_TOP" nil) error("Text failed\n"))
unless(axlDBCreateText("VALUE" 0:0 style "COMPONENT VALUE/ASSEMBLY_TOP" nil) error("Text failed\n"))
unless(axlSaveDesign(?design "D:/001DIY/005lib/01AIEDA/learning/examples/lesson09_qfn_qfp_20261018/library/l09_stm32f103c8_lqfp48.dra" ?noMru t ?noConfirm t) error("Save failed\n"))
unless(axlCompileSymbol(?symbol "D:/001DIY/005lib/01AIEDA/learning/examples/lesson09_qfn_qfp_20261018/library/l09_stm32f103c8_lqfp48") error("Compile failed\n"))
fprintf(f "L09 CREATE COMPLETE\n")
close(f)
t))
