procedure(l9Read(outDir)
 let((f pf df sf tf xf vf af d pins syms s p pad box layer kind objs obj poly parent netname)
 f=outfile(strcat(outDir "/verify.txt"))
 pf=outfile(strcat(outDir "/pins.tsv"))
 df=outfile(strcat(outDir "/pads.tsv"))
 sf=outfile(strcat(outDir "/shapes.tsv"))
 tf=outfile(strcat(outDir "/texts.tsv"))
 xf=outfile(strcat(outDir "/symbols.tsv"))
 vf=outfile(strcat(outDir "/vias.tsv"))
 af=outfile(strcat(outDir "/polygons.tsv"))
 unless(f && pf && df && sf && tf && xf && vf && af error("Output open failed\n"))
 d=axlDBGetDesign()
 fprintf(f "L09 READ START\ndesign=%L units=%L drcs=%d drcState=%L\n" axlCurrentDesign() axlDBGetDesignUnits() length(d->drcs) d->drcState)
 fprintf(pf "number\tpadstack\tx\ty\trelx\trely\trotation\tmirrored\tthrough\thole\ttop\tbottom\tnet\n")
 fprintf(df "number\tx\ty\tlayer\tkind\tfigure\twidth\theight\tradius\tcorners\tbbox\n")
 fprintf(sf "layer\tbbox\tfilled\tarea\tproperties\n")
 fprintf(tf "layer\ttext\tx\ty\trotation\tmirrored\tbbox\n")
 fprintf(xf "name\tx\ty\trotation\tmirrored\tpins\n")
 fprintf(vf "padstack\tx\ty\tdrill\tplating\tthrough\tnet\n")
 fprintf(af "number\tx\ty\tlayer\tarea\tbbox\tvertices\n")
 pins=d->pins
 foreach(s d->symbols
  fprintf(xf "%L\t%L\t%L\t%L\t%L\t%d\n" s->name car(s->xy) cadr(s->xy) s->rotation s->isMirrored length(s->pins))
  pins=append(pins s->pins))
 foreach(p pins
  netname=nil
  when(axlIsDBIDType(p->net) netname=p->net->name)
  fprintf(pf "%L\t%L\t%L\t%L\t%L\t%L\t%L\t%L\t%L\t%L\t%L\t%L\t%L\n" p->number p->name car(p->xy) cadr(p->xy) car(p->relxy) cadr(p->relxy) p->rotation p->isMirrored p->isThrough p->definition->holeType axlPadOnLayer(p "TOP") axlPadOnLayer(p "BOTTOM") netname)
  foreach(layer list("ETCH/TOP" "ETCH/L2" "ETCH/L3" "ETCH/BOTTOM" "PIN/SOLDERMASK_TOP" "PIN/SOLDERMASK_BOTTOM" "PIN/PASTEMASK_TOP" "PIN/PASTEMASK_BOTTOM")
   pad=if(axlIsLayer(layer) then axlDBGetPad(p layer "REGULAR") else nil)
   box=if(pad then pad->bBox else nil)
   fprintf(df "%L\t%L\t%L\t%L\t%L\t%L\t%L\t%L\t%L\t%L\t%L\n" p->number car(p->xy) cadr(p->xy) layer "REGULAR" if(pad then pad->figureName else nil) if(box then car(cadr(box))-car(car(box)) else nil) if(box then cadr(cadr(box))-cadr(car(box)) else nil) if(pad then pad->radius else nil) if(pad then pad->corners else nil) box)
   when(member(layer list("ETCH/TOP" "ETCH/BOTTOM" "PIN/PASTEMASK_TOP" "PIN/PASTEMASK_BOTTOM"))
    foreach(poly axlPolyFromDB(p ?layer layer ?padType 'REGULAR)
     fprintf(af "%L\t%L\t%L\t%L\t%L\t%L\t%L\n" p->number car(p->xy) cadr(p->xy) layer poly->area poly->bBox poly->vertices)))))
 objs=axlExtractMap("C:/Program0/Cadence/SPB172/share/pcb/text/views/fgeo_bv.txt" nil)
 foreach(obj objs
  when(equal(obj->objType "text")
   fprintf(tf "%L\t%L\t%L\t%L\t%L\t%L\t%L\n" obj->layer obj->text car(obj->xy) cadr(obj->xy) obj->rotation obj->isMirrored obj->bBox))
  when(equal(obj->objType "shape")
   poly=car(axlPolyFromDB(obj))
   fprintf(sf "%L\t%L\t%L\t%L\t%L\n" obj->layer obj->bBox obj->fill if(poly then poly->area else nil) axlDBGetProperties(obj nil)))
  when(equal(obj->objType "via")
   netname=nil
   when(axlIsDBIDType(obj->net) netname=obj->net->name)
   fprintf(vf "%L\t%L\t%L\t%L\t%L\t%L\t%L\n" obj->name car(obj->xy) cadr(obj->xy) obj->definition->drillDiameter obj->definition->plating obj->isThrough netname)
   foreach(layer list("ETCH/TOP" "ETCH/L2" "ETCH/L3" "ETCH/BOTTOM" "PIN/SOLDERMASK_TOP" "PIN/SOLDERMASK_BOTTOM" "PIN/PASTEMASK_TOP" "PIN/PASTEMASK_BOTTOM")
    pad=axlDBGetPad(obj layer "REGULAR") box=if(pad then pad->bBox else nil)
    fprintf(df "%L\t%L\t%L\t%L\t%L\t%L\t%L\t%L\t%L\t%L\t%L\n" "VIA" car(obj->xy) cadr(obj->xy) layer "REGULAR" if(pad then pad->figureName else nil) if(box then car(cadr(box))-car(car(box)) else nil) if(box then cadr(cadr(box))-cadr(car(box)) else nil) if(pad then pad->radius else nil) if(pad then pad->corners else nil) box))))
 foreach(s axlXSectionGet(nil 'all) fprintf(f "layer=%L type=%L\n" s->name s->layerType))
 fprintf(f "L09 READ COMPLETE\n")
 foreach(p list(f pf df sf tf xf vf af) close(p))
 t))
procedure(l9Board(libDir outDir)
 let((f result s p def xs c n)
 unless(equal(axlCurrentDesign() "l09_placement_4layer") error("Wrong board\n"))
 axlDBChangeDesignUnits("millimeters" 3)
 axlDBChangeDesignExtents(list(-50:-40 50:40))
 axlSetVariable("padpath" list(libDir)) axlSetVariable("psmpath" list(libDir))
 f=outfile(strcat(outDir "/create.txt"))
 foreach(n list("L2" "L3")
  def=axlXSectionModify(?name n ?layerType "CONDUCTOR" ?material "COPPER" ?thickness 0.035)
  unless(axlXSectionCreate(nil 'bottom def) error("Conductor failed\n"))
  def=axlXSectionModify(?layerType "DIELECTRIC" ?material "FR-4" ?thickness 0.4)
  unless(axlXSectionCreate(nil 'bottom def) error("Dielectric failed\n")))

 foreach(c list(list("l09_stm32f103c8_lqfp48" 15) list("l09_tps62130_rgt16_single" 0) list("l09_tps62130_rgt16_split" -15))
  foreach(n list(list(-20 nil 0) list(0 nil 90) list(20 t 0))
   result=axlDBCreateSymbol(list(car(c) "PACKAGE") list(car(n) cadr(c)) cadr(n) caddr(n))
   unless(result error("Symbol create failed\n")) s=car(result)
  ))
 foreach(c list(-20.58:-15.58 -20.58:-14.42 -19.42:-15.58 -19.42:-14.42 -20:-15)
  unless(axlDBCreateVia("l09_thermal_via020_c040" c nil nil 0 nil) error("Thermal via failed\n")))
 unless(axlSaveDesign(?design strcat(libDir "/l09_placement_4layer.brd") ?noMru t ?noConfirm t) error("Board save failed\n"))
 fprintf(f "L09 BOARD COMPLETE\n") close(f) t))
