procedure(hiBindExistingShape(f id net layer)
 let((boundaries b)
  boundaries=nil
  foreach(s axlDBGetShapes(strcat("ETCH/" layer))
   when(s->net && equal(s->net->name net) && s->shapeBoundary
    b=s->shapeBoundary
    unless(member(b boundaries) boundaries=cons(b boundaries))))
  unless(length(boundaries)==1 error("Expected exactly one existing dynamic application shape %s %s found=%L\n" net layer boundaries))
  b=car(boundaries)
  fprintf(f "HI_BIND_EXISTING_SHAPE id=%L net=%L layer=%L boundary=%L\n" id net layer b->??)
  hiReg(id "shape" b)
  b))
procedure(hiVoid(f shapeId points)
 let((row shape opened void ret)
  row=assoc(shapeId hiRegistry)
  unless(row error("Void requires known shape id %s\n" shapeId))
  shape=caddr(row)
  opened=axlDBOpenShape(shape)
  unless(opened error("Cannot open shape for permanent void\n"))
  void=axlDBCreateVoid(opened hiClosedPath(points))
  unless(void error("Cannot create permanent void\n"))
  ret=axlDBCreateCloseShape(opened t)
  unless(ret error("Cannot close shape after permanent void\n"))
  hiRegistry=remove(row hiRegistry)
  hiReg(shapeId "shape" car(ret))
  fprintf(f "HI_PERMANENT_VOID shapeId=%L polygon=%L void=%L actual=%L\n" shapeId points void->?? car(ret)->??)
  t))
procedure(hiHSEIsolationChallenge(out anchorXY localLayer guardPoints)
 let((f mark via beforeCount graph quietShape guard)
  f=outfile(strcat(out "/hi_hse_isolation_challenge.txt"))
  axlShapeDynamicUpdate(nil t) axlDBRefreshId(nil)
  axlDRCUpdate(t) axlDBRefreshId(nil)
  beforeCount=length(axlDBGetDesign()->drcs)
  hiProof(f "C22.2" "C23.2" t)
  hiProof(f "C22.2" "U1.47" t)
  hiProof(f "C22.2" "Y1.2" t)
  mark=axlDBTransactionStart()
  unless(mark error("Cannot start HSE isolation negative-test transaction\n"))
  via=hiResolvePoint("GND" "TOP" anchorXY "via")
  fprintf(f "HSE_NEGATIVE_DELETE_ONLY_ANCHOR=%L\n" via->??)
  unless(axlDeleteObject(via) error("Cannot delete single HSE bridge via\n"))
  axlShapeDynamicUpdate(nil t) axlDBRefreshId(nil)
  hiProof(f "C22.2" "C23.2" t)
  graph=gConnectedObjects(gPin("C22" "2"))
  quietShape=setof(s graph equal(s->objType "shape") && equal(s->layer strcat("ETCH/" localLayer)) && s->fill)
  unless(quietShape error("Local island disconnected in anchor-negative test\n"))
  foreach(guardXY guardPoints
   guard=hiResolvePoint("GND" "TOP" guardXY "point")
   fprintf(f "NEGATIVE_LOCAL_REFERENCE count=%d guardXY=%L guardReached=%L\n" length(quietShape) guardXY if(member(guard graph) then t else nil))
   unless(member(guard graph) error("Quiet guard disconnected in anchor-negative test\n")))
  hiProof(f "C22.2" "U1.47" nil)
  hiProof(f "C22.2" "Y1.2" nil)
  hiProof(f "C15.2" "U1.47" t)
  hiProof(f "Y1.2" "Y1.4" t)
  hiProof(f "Y1.2" "U1.47" t)
  fprintf(f "HSE_NEGATIVE_ACTUAL_GND_NET_UNCONNECTED=%L\n" axlDBFindByName('net "GND")->unconnected)
  unless(axlDBTransactionRollback(mark) error("Cannot rollback HSE anchor deletion\n"))
  axlShapeDynamicUpdate(nil t) axlDBRefreshId(nil)
  hiProof(f "C22.2" "C23.2" t)
  hiProof(f "C22.2" "U1.47" t)
  hiProof(f "C22.2" "Y1.2" t)
  axlDRCUpdate(t) f29DumpDRC(f "HSE_ANCHOR_RESTORED")
  unless(length(axlDBGetDesign()->drcs)==beforeCount error("Restored HSE DRC count differs\n"))
  fprintf(f "HSE_ISOLATION_NEGATIVE_TEST_COMPLETE_NO_SAVE\n") close(f) t))

procedure(hiAssignNetClass(f name domain cset nets)
 let((nc net old prop)
  nc=axlNetClassCreate(name domain)
  unless(nc error("Cannot create scoped netclass %s\n" name))
  prop=if(equal(domain 'physical) then "PHYSICAL_CONSTRAINT_SET" else "SPACING_CONSTRAINT_SET")
  unless(axlDBAddProp(list(nc) list(list(prop cset))) error("Cannot assign scoped class CSet\n"))
  foreach(n nets
   net=axlDBFindByName('net n)
   unless(net error("Missing logical net while assigning class\n"))
   old=axlNetClassGet(net domain t)
   when(old unless(axlNetClassRemove(old net) error("Cannot remove old domain class member\n")))
   unless(axlNetClassAdd(nc net) error("Cannot add scoped class member\n"))
   fprintf(f "HI_CLASS_REASSIGN net=%L domain=%L old=%L new=%L baseCSet=%L directNetProperties=%L\n" n domain if(old then old->name else nil) name cset axlDBGetProperties(net)))
  axlCNSMapUpdate()
  t))
