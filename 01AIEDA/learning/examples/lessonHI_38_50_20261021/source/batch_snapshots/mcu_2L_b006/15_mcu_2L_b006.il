procedure(hiBatchProgram()
 let((f)
  f=outfile("D:/001DIY/005lib/01AIEDA/learning/examples/lessonHI_38_50_20261021/logs/mcu_2L_b006/hi_batch_execution.txt")
  hiRegistry=nil
  hiNodeDefinitions=list(list("HSE_IN" "OSC_IN" "TOP" list(40.75 31.25) "point") list("HSE_IN_LOAD" "OSC_IN" "TOP" list(44.4 33.7) "point") list("HSE_OUT" "OSC_OUT" "TOP" list(40.25 31.25) "point") list("HSE_XTAL_OUT" "XTAL_OUT" "TOP" list(40.2 34.7748) "point") list("HSE_OUT_LOAD" "XTAL_OUT" "TOP" list(40.3 37.7) "point") list("HSE_LOCAL_C22" "GND" "TOP" list(47.1 35.5748) "via") list("HSE_LOCAL_C23" "GND" "TOP" list(37.7 37.7) "via") list("HSE_SINGLE_ANCHOR" "GND" "TOP" list(45.45 28.85) "via") list("HSE_C22_RETURN" "GND" "TOP" list(46.2 35.5748) "point") list("HSE_C23_RETURN" "GND" "TOP" list(38.2252 37.7) "point") list("HSE_GUARD_LEFT_NORTH" "GND" "TOP" list(37.7 37.7) "point") list("HSE_GUARD_RIGHT_NORTH" "GND" "TOP" list(47.1 35.5748) "point") list("HSE_GUARD_RIGHT_LOWER" "GND" "TOP" list(47.8 35.5748) "point") list("HSE_CASE_APP" "GND" "TOP" list(43.2 40.8) "via") list("HSE_CASE4_APP" "GND" "TOP" list(42.0 33.7) "point") list("HSE_CASE2_APP" "GND" "TOP" list(44.4 37.7) "point") list("VDDA_PIN_CAP" "VDDA" "TOP" list(38.75 31.25) "point") list("VDDA_CAP_BULK" "VDDA" "TOP" list(37.0 33.2) "point") list("VDDA_BULKS" "VDDA" "TOP" list(34.8 37.0) "point") list("VDDA_FILTER" "VDDA" "TOP" list(32.2 37.0) "point") list("VSSA8_APP" "GND" "TOP" list(38.7 29.5) "via") list("VSSA8_INWARD" "GND" "TOP" list(39.25 31.25) "point") list("C18_APP_GND" "GND" "TOP" list(37.9 34.7748) "via") list("C18_APP_GND_TRACE" "GND" "TOP" list(37.0 34.7748) "point") list("C19_APP_GND" "GND" "TOP" list(34.8 39.7) "via") list("C19_APP_GND_TRACE" "GND" "TOP" list(34.8 38.5748) "point") list("C20_APP_GND" "GND" "TOP" list(32.2 40.1) "via") list("C20_APP_GND_TRACE" "GND" "TOP" list(32.2 39.032) "point") list("C24_APP_GND" "GND" "TOP" list(34.4 35.7) "via") list("C24_APP_GND_TRACE" "GND" "TOP" list(34.8 34.5748) "point") list("C21_APP_GND" "GND" "TOP" list(36.95 36.25) "via") list("C21_APP_GND_TRACE" "GND" "TOP" list(37.8016 36.25) "point") list("ADC_PIN_CAP" "ADC0" "TOP" list(38.25 31.25) "point") list("ADC_CAP_SERIES" "ADC0" "TOP" list(34.8 33.0) "point") list("ADC_INPUT" "ADC_IN" "TOP" list(31.1016 35.0) "point") list("NRST_PIN_CAP" "NRST" "TOP" list(39.75 31.25) "point") list("NRST_SERVICE" "NRST" "TOP" list(38.7 35.3) "via") list("NRST_SERVICE_TAP" "NRST" "TOP" list(39.35 35.3) "point") list("VBAT_PIN_CAP" "V3V3" "TOP" list(42.75 31.25) "point") list("VBAT_C17_APP" "GND" "TOP" list(48.9 32.4) "via") list("VBAT_C17_RETURN" "GND" "TOP" list(47.7764 32.4) "point") list("HI_GUARD_LEFT_END" "GND" "TOP" list(42.2 39.8) "point") list("HI_GUARD_RIGHT_END" "GND" "TOP" list(44.2 39.8) "point") list("HI_GUARD_RIGHT_LOWER_END" "GND" "TOP" list(47.8 33.5) "point"))
  hiMove(f "C21" list(39.478 36.25) 180.0)
  hiMove(f "C24" list(34.8 32.8984) 90.0)
  hiMove(f "R23" list(32.9 33.02) 180.0)
  hiCSet(f 'physical "HI_MCU_NORTH_P_VDDA_2L" "HI2L_P_VDDA" list(list('necklength_max "1.4 MM")))
  hiCSet(f 'physical "HI_MCU_NORTH_P_GROUND_2L" "HI2L_P_GROUND" list(list('necklength_max "1.4 MM")))
  hiCSet(f 'spacing "HI_MCU_NORTH_S_ADC_2L" "HI2L_S_ADC" list(list('smdpin_line "0.2 MM") list('line_line "0.2 MM")))
  hiCSet(f 'spacing "HI_MCU_NORTH_S_OSCILLATOR_2L" "HI2L_S_OSCILLATOR" list(list('smdpin_line "0.2 MM") list('line_line "0.2 MM")))
  hiCSet(f 'spacing "HI_MCU_NORTH_S_POWER_2L" "HI2L_S_POWER_LV" list(list('smdpin_line "0.2 MM") list('line_line "0.2 MM")))
  hiCSet(f 'spacing "HI_MCU_NORTH_S_VDDA_2L" "HI2L_S_VDDA" list(list('smdpin_line "0.2 MM") list('line_line "0.2 MM")))
  hiCSet(f 'spacing "HI_MCU_NORTH_S_GROUND_2L" "HI2L_S_GROUND" list(list('smdpin_line "0.2 MM") list('line_line "0.2 MM")))
  hiRegion(f "HI_MCU_NORTH_ESCAPE" "TOP" list(list(37.7 29.25) list(43.9 29.25) list(43.9 32.9) list(37.7 32.9)) list(list("HI2L_VDDA_P" 'physical "HI_MCU_NORTH_P_VDDA_2L") list("HI2L_GROUND_P" 'physical "HI_MCU_NORTH_P_GROUND_2L") list("HI2L_ADC_S" 'spacing "HI_MCU_NORTH_S_ADC_2L") list("HI2L_OSCILLATOR_S" 'spacing "HI_MCU_NORTH_S_OSCILLATOR_2L") list("HI2L_POWER_LV_S" 'spacing "HI_MCU_NORTH_S_POWER_2L") list("HI2L_VDDA_S" 'spacing "HI_MCU_NORTH_S_VDDA_2L") list("HI2L_GROUND_S" 'spacing "HI_MCU_NORTH_S_GROUND_2L")))
  hiBindExistingShape(f "HI_APP_GND_BOTTOM" "GND" "BOTTOM")
  hiVoid(f "HI_APP_GND_BOTTOM" list(list(44.75 28.15) list(46.15 28.15) list(46.15 31.4) list(45.65 31.9) list(45.65 32.85) list(47.85 32.85) list(47.85 39.75) list(36.85 39.75) list(36.85 36.45) list(39.65 36.45) list(39.65 32.45) list(40.25 32.45) list(40.25 31.6) list(44.25 31.6) list(44.75 31.1)))
  hiShape(f "HI_HSE_QUIET" "GND" "BOTTOM" list(list(45.1 28.5) list(45.8 28.5) list(45.8 31.25) list(45.1 31.95) list(45.3 31.95) list(45.3 33.2) list(47.5 33.2) list(47.5 39.4) list(37.2 39.4) list(37.2 36.8) list(40.0 36.8) list(40.0 32.8) list(40.6 32.8) list(40.6 31.95) list(44.4 31.95) list(45.1 31.25)) nil list())
  hiRoute(f "HSE_IN" "OSC_IN" "TOP" list(list(40.75 31.25) list(40.75 32.3) list(43.0 32.3) list(44.4 33.7)) list(0.2 0.2 0.2))
  hiRoute(f "HSE_IN_LOAD" "OSC_IN" "TOP" list(list(44.4 33.7) list(44.7 34.0) list(46.2 34.0)) list(0.2 0.2))
  hiRoute(f "HSE_OUT" "OSC_OUT" "TOP" list(list(40.25 31.25) list(40.25 32.15) list(40.2 32.2) list(40.2 33.2)) list(0.2 0.2 0.2))
  hiRoute(f "HSE_XTAL_OUT" "XTAL_OUT" "TOP" list(list(40.2 34.7748) list(40.3 34.8748) list(40.3 37.7) list(42.0 37.7)) list(0.2 0.2 0.2))
  hiRoute(f "HSE_OUT_LOAD" "XTAL_OUT" "TOP" list(list(40.3 37.7) list(39.8 37.7)) list(0.2))
  hiVia(f "HSE_LOCAL_C22" "GND" list(47.1 35.5748) "L28_VIA030_C060")
  hiVia(f "HSE_LOCAL_C23" "GND" list(37.7 37.7) "L28_VIA030_C060")
  hiVia(f "HSE_SINGLE_ANCHOR" "GND" list(45.45 28.85) "L28_VIA030_C060")
  hiRoute(f "HSE_C22_RETURN" "GND" "TOP" list(list(46.2 35.5748) list(47.1 35.5748)) list(0.6))
  hiRoute(f "HSE_C23_RETURN" "GND" "TOP" list(list(38.2252 37.7) list(37.7 37.7)) list(0.6))
  hiRoute(f "HSE_GUARD_LEFT_NORTH" "GND" "TOP" list(list(37.7 37.7) list(37.0 37.7) list(37.0 39.8) list(42.2 39.8)) list(0.6 0.6 0.6))
  hiRoute(f "HSE_GUARD_RIGHT_NORTH" "GND" "TOP" list(list(47.1 35.5748) list(47.8 35.5748) list(47.8 39.8) list(44.2 39.8)) list(0.6 0.6 0.6))
  hiRoute(f "HSE_GUARD_RIGHT_LOWER" "GND" "TOP" list(list(47.8 35.5748) list(47.8 33.5)) list(0.6))
  hiVia(f "HSE_CASE_APP" "GND" list(43.2 40.8) "L28_VIA030_C060")
  hiRoute(f "HSE_CASE4_APP" "GND" "TOP" list(list(42.0 33.7) list(42.0 34.8) list(43.2 36.0) list(43.2 40.8)) list(0.6 0.6 0.6))
  hiRoute(f "HSE_CASE2_APP" "GND" "TOP" list(list(44.4 37.7) list(43.2 38.9) list(43.2 40.8)) list(0.6 0.6))
  hiRoute(f "VDDA_PIN_CAP" "VDDA" "TOP" list(list(38.75 31.25) list(38.75 32.55) list(38.1 33.2) list(37.0 33.2)) list(0.25 0.6 0.6))
  hiRoute(f "VDDA_CAP_BULK" "VDDA" "TOP" list(list(37.0 33.2) list(36.5 33.2) list(35.9 33.8) list(35.9 35.9) list(34.8 37.0)) list(0.6 0.6 0.6 0.6))
  hiRoute(f "VDDA_BULKS" "VDDA" "TOP" list(list(34.8 37.0) list(32.2 37.0)) list(0.6))
  hiRoute(f "VDDA_FILTER" "VDDA" "TOP" list(list(32.2 37.0) list(31.4 37.0) list(30.9 37.5) list(30.9 38.1748) list(30.5 38.5748) list(29.5 38.5748)) list(0.6 0.6 0.6 0.6 0.6))
  hiVia(f "VSSA8_APP" "GND" list(38.7 29.5) "L28_VIA030_C060")
  hiRoute(f "VSSA8_INWARD" "GND" "TOP" list(list(39.25 31.25) list(39.25 30.05) list(38.7 29.5)) list(0.25 0.6))
  hiVia(f "C18_APP_GND" "GND" list(37.9 34.7748) "L28_VIA030_C060")
  hiRoute(f "C18_APP_GND_TRACE" "GND" "TOP" list(list(37.0 34.7748) list(37.9 34.7748)) list(0.6))
  hiVia(f "C19_APP_GND" "GND" list(34.8 39.7) "L28_VIA030_C060")
  hiRoute(f "C19_APP_GND_TRACE" "GND" "TOP" list(list(34.8 38.5748) list(34.8 39.7)) list(0.6))
  hiVia(f "C20_APP_GND" "GND" list(32.2 40.1) "L28_VIA030_C060")
  hiRoute(f "C20_APP_GND_TRACE" "GND" "TOP" list(list(32.2 39.032) list(32.2 40.1)) list(0.6))
  hiVia(f "C24_APP_GND" "GND" list(34.4 35.7) "L28_VIA030_C060")
  hiRoute(f "C24_APP_GND_TRACE" "GND" "TOP" list(list(34.8 34.5748) list(34.4 34.9748) list(34.4 35.7)) list(0.6 0.6))
  hiVia(f "C21_APP_GND" "GND" list(36.95 36.25) "L28_VIA030_C060")
  hiRoute(f "C21_APP_GND_TRACE" "GND" "TOP" list(list(37.8016 36.25) list(36.95 36.25)) list(0.6))
  hiRoute(f "ADC_PIN_CAP" "ADC0" "TOP" list(list(38.25 31.25) list(38.25 32.2) list(37.8 32.2) list(37.7 32.3) list(35.5 32.3) list(34.8 33.0)) list(0.2 0.2 0.2 0.2 0.2))
  hiRoute(f "ADC_CAP_SERIES" "ADC0" "TOP" list(list(34.8 33.0) list(32.8 35.0) list(32.6764 35.0)) list(0.2 0.2))
  hiRoute(f "ADC_INPUT" "ADC_IN" "TOP" list(list(31.1016 35.0) list(30.8 35.0) list(29.8 34.0) list(26.27 34.0)) list(0.2 0.2 0.2))
  hiRoute(f "NRST_PIN_CAP" "NRST" "TOP" list(list(39.75 31.25) list(39.75 32.05) list(39.35 32.45) list(39.35 35.3) list(39.35 36.2236) list(39.3764 36.25)) list(0.2 0.2 0.2 0.2 0.2))
  hiVia(f "NRST_SERVICE" "NRST" list(38.7 35.3) "L28_VIA030_C060")
  hiRoute(f "NRST_SERVICE_TAP" "NRST" "TOP" list(list(39.35 35.3) list(38.7 35.3)) list(0.2))
  hiRoute(f "VBAT_PIN_CAP" "V3V3" "TOP" list(list(42.75 31.25) list(43.55 31.25) list(46.2016 31.25) list(46.2016 32.4)) list(0.25 0.6 0.6))
  hiVia(f "VBAT_C17_APP" "GND" list(48.9 32.4) "L28_VIA030_C060")
  hiRoute(f "VBAT_C17_RETURN" "GND" "TOP" list(list(47.7764 32.4) list(48.9 32.4)) list(0.6))
  hiHSEIsolationChallenge("D:/001DIY/005lib/01AIEDA/learning/examples/lessonHI_38_50_20261021/logs/mcu_2L_b006" list(45.45 28.85) "BOTTOM" list(list(42.2 39.8) list(44.2 39.8) list(47.8 33.5)))
  hiFinalize(f "D:/001DIY/005lib/01AIEDA/learning/examples/lessonHI_38_50_20261021/logs/mcu_2L_b006" "D:/001DIY/005lib/01AIEDA/learning/examples/lessonHI_38_50_20261021/native/HI_2L_mcu_2L_b006.brd" "D:/001DIY/005lib/01AIEDA/learning/examples/lessonHI_38_50_20261021/library" list(list("U1.5" "Y1.1" t) list("Y1.1" "C22.1" t) list("U1.6" "R31.1" t) list("R31.2" "Y1.3" t) list("R31.2" "C23.1" t) list("C22.2" "HSE_LOCAL_C22" t) list("C23.2" "HSE_LOCAL_C23" t) list("Y1.4" "HSE_CASE_APP" t) list("Y1.2" "HSE_CASE_APP" t) list("U1.9" "C18.1" t) list("C18.1" "C19.1" t) list("C19.1" "C20.1" t) list("C20.1" "R26.2" t) list("U1.8" "VSSA8_APP" t) list("C18.2" "C18_APP_GND" t) list("C19.2" "C19_APP_GND" t) list("C20.2" "C20_APP_GND" t) list("C24.2" "C24_APP_GND" t) list("C21.2" "C21_APP_GND" t) list("U1.10" "C24.1" t) list("C24.1" "R32.2" t) list("R32.1" "J10.1" t) list("U1.7" "C21.1" t) list("C21.1" "NRST_SERVICE" t) list("U1.1" "C17.1" t) list("C17.2" "VBAT_C17_APP" t) list("C22.2" "HI_HSE_QUIET" t) list("C23.2" "HI_HSE_QUIET" t) list("HI_GUARD_LEFT_END" "C23.2" t) list("HI_GUARD_RIGHT_END" "C22.2" t) list("HI_GUARD_RIGHT_LOWER_END" "C22.2" t) list("C22.2" "U1.47" t)))
  t))
