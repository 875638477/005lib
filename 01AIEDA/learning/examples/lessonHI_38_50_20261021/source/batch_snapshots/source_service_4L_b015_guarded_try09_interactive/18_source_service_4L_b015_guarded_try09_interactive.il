procedure(hiBatchProgram()
 let((f)
  f=outfile("D:/001DIY/005lib/01AIEDA/learning/examples/lessonHI_38_50_20261021/logs/source_service_4L_b015_guarded_try09_interactive/hi_batch_execution.txt")
  fprintf(f "HI_BATCH_DRC_BEFORE=%L\n" axlDBControl('drcEnable))
  unwindProtect(
   progn(
    axlDBControl('drcEnable nil)
    fprintf(f "HI_ASSEMBLY_ONLINE_DRC_TEMPORARILY_DISABLED=%L\n" axlDBControl('drcEnable))
    hiRegistry=nil
    hiNodeDefinitions=list(list("GPIO_NORTH_PC15_DIRECT_WEST" "GPIO_PC15" "BOTTOM" list(40.3 28.9) "point") list("GPIO_PA1_INWARD_FANOUT" "GPIO_PA1" "TOP" list(37.75 31.25) "point") list("GPIO_PA1_INWARD_VIA" "GPIO_PA1" "TOP" list(37.5 29.6) "via") list("GPIO_PA2_INWARD_FANOUT" "GPIO_PA2" "TOP" list(37.25 31.25) "point") list("GPIO_PA2_INWARD_VIA" "GPIO_PA2" "TOP" list(36.6 30.4) "via") list("GPIO_PA3_INWARD_FANOUT" "GPIO_PA3" "TOP" list(35.75 29.75) "point") list("GPIO_PA3_INWARD_VIA" "GPIO_PA3" "TOP" list(35.2 31.65) "via") list("GPIO_NORTH_COMMON_RETURN" "GND" "TOP" list(39.5 28.0) "via") list("SOUTH_SOURCE_25_NECK" "GPIO_PB12" "TOP" list(37.25 22.75) "point") list("SOUTH_SOURCE_25_VIA" "GPIO_PB12" "TOP" list(37.0 21.25) "via") list("SOUTH_SOURCE_26_NECK" "GPIO_PB13" "TOP" list(37.75 22.75) "point") list("SOUTH_SOURCE_26_VIA" "GPIO_PB13" "TOP" list(37.5 20.75) "via") list("SOUTH_SOURCE_27_NECK" "GPIO_PB14" "TOP" list(38.25 22.75) "point") list("SOUTH_SOURCE_27_VIA" "GPIO_PB14" "TOP" list(38.0 21.25) "via") list("SOUTH_SOURCE_28_NECK" "GPIO_PB15" "TOP" list(38.75 22.75) "point") list("SOUTH_SOURCE_28_VIA" "GPIO_PB15" "TOP" list(38.5 20.7) "via") list("SOUTH_SOURCE_29_NECK" "USB_ATTACH_N" "TOP" list(39.25 22.75) "point") list("SOUTH_SOURCE_29_VIA" "USB_ATTACH_N" "TOP" list(39.0 21.2) "via") list("SOUTH_SOURCE_30_NECK" "PA9_UART_TX" "TOP" list(39.75 22.75) "point") list("SOUTH_SOURCE_30_VIA" "PA9_UART_TX" "TOP" list(39.7 21.7) "via") list("SOUTH_SOURCE_31_NECK" "PA10_UART_RX" "TOP" list(40.25 22.75) "point") list("SOUTH_SOURCE_31_VIA" "PA10_UART_RX" "TOP" list(40.0 20.5) "via") list("SOUTH_RETURN_WEST" "GND" "TOP" list(35.8 21.95) "via") list("SOUTH_RETURN_MID" "GND" "TOP" list(38.0 20.0) "via") list("SOUTH_RETURN_EAST" "GND" "TOP" list(38.8 19.7) "via") list("SOUTH_SOURCE_34_NECK" "SWDIO" "TOP" list(41.75 22.75) "point") list("SOUTH_SOURCE_34_VIA" "SWDIO" "TOP" list(41.52 21.25) "via") list("SOUTH_C14_GND_NECK" "GND" "TOP" list(42.25 22.75) "point") list("SOUTH_C14_GND_WIDE" "GND" "TOP" list(42.28 21.37) "point") list("SOUTH_GPIO12_BOTTOM_NECK" "GPIO_PB12" "BOTTOM" list(37.0 21.25) "point") list("SOUTH_GPIO12_BOTTOM_EXIT" "GPIO_PB12" "BOTTOM" list(36.5 21.25) "point") list("SOUTH_GPIO13_BOTTOM_NECK" "GPIO_PB13" "BOTTOM" list(37.5 20.75) "point") list("SOUTH_GPIO14_BOTTOM_NECK" "GPIO_PB14" "BOTTOM" list(38.0 21.25) "point") list("SOUTH_GPIO14_BOTTOM_EXIT" "GPIO_PB14" "BOTTOM" list(38.0 21.9) "point") list("SOUTH_GPIO15_BOTTOM_NECK" "GPIO_PB15" "BOTTOM" list(38.5 20.7) "point") list("LEFT_C13_VDD24_NECK" "V3V3" "TOP" list(35.75 24.25) "point") list("LEFT_C13_VDD24_WIDE" "V3V3" "TOP" list(35.1 23.2) "point") list("LEFT_C13_VSS23_NECK" "GND" "TOP" list(35.75 24.75) "point") list("LEFT_C13_VSS23_WIDE" "GND" "TOP" list(34.7 24.75) "point") list("LEFT_C13_COMMON_RETURN" "GND" "TOP" list(34.0 24.1748) "point") list("LEFT_V3_PERIPHERAL_REROUTE" "V3V3" "TOP" list(33.3 22.5) "point") list("LEFT_SOURCE_19_NECK" "GPIO_PB1" "TOP" list(35.75 26.75) "point") list("LEFT_SOURCE_19_VIA" "GPIO_PB1" "TOP" list(38.3 27.35) "via") list("LEFT_SOURCE_21_NECK" "GPIO_PB10" "TOP" list(35.75 25.75) "point") list("LEFT_SOURCE_21_VIA" "GPIO_PB10" "TOP" list(38.0 26.4) "via") list("LEFT_SOURCE_22_NECK" "GPIO_PB11" "TOP" list(35.75 25.25) "point") list("LEFT_SOURCE_22_VIA" "GPIO_PB11" "TOP" list(33.7 25.3) "via") list("LEFT_BOOT1_SOURCE_NECK" "BOOT1" "TOP" list(35.75 26.25) "point") list("LEFT_BOOT1_SOURCE_VIA" "BOOT1" "TOP" list(34.4 26.0) "via") list("LEFT07_VBUS18_SOURCE" "VBUS_PRESENT_N" "TOP" list(35.75 27.25) "point") list("LEFT07_VBUS18_VIA" "VBUS_PRESENT_N" "TOP" list(34.6 26.85) "via") list("NSS01_MAIN_SOURCE" "PA4_SPI_NSS" "TOP" list(34.8 31.15) "point") list("NSS01_LOCAL_PULLUP_STUB" "PA4_SPI_NSS" "TOP" list(33.3984 32.1) "point") list("NSS01_SCK_SOURCE" "PA5_SPI_SCK" "TOP" list(34.385 30.215) "point") list("NSS01_ADC_SERIES_TO_LOCAL_CAP" "ADC0" "TOP" list(34.8 33.0) "point") list("NSS01_ADC_INPUT" "ADC_IN" "TOP" list(31.1016 35.5) "point") list("NSS01_R25_SUPPLY_VIA" "V3V3" "TOP" list(30.4 33.7) "via") list("NSS01_R25_SUPPLY_BOTTOM" "V3V3" "BOTTOM" list(30.7 32.0) "point") list("NSS01_R25_SUPPLY_TOP" "V3V3" "TOP" list(30.4 33.7) "point") list("NSS01_4L_ADD_2" "SPI_SCK" "TOP" list(32.0252 30.7) "point") list("NSS01_4L_ADD_6" "SPI_NSS" "TOP" list(31.8236 32.1) "point") list("RIGHT_PC14_SOUTH_BYPASS" "GPIO_PC14" "BOTTOM" list(43.6 25.2) "point") list("RIGHT_PC14_FINAL" "GPIO_PC14" "TOP" list(49.2 25.2) "via") list("RIGHT_PC14_RETURN" "GND" "TOP" list(48.2 25.0) "via") list("RIGHT_VSS47_NECK" "GND" "TOP" list(44.25 29.25) "point") list("RIGHT_VSS47_CAP_GROUND" "GND" "TOP" list(45.4 29.5) "point") list("HSE_SINGLE_ANCHOR_REWORK" "GND" "TOP" list(46.35 29.4) "via") list("RIGHT_C15_COMMON_GND" "GND" "TOP" list(48.25 28.7252) "via") list("RIGHT_VDD48_NECK" "V3V3" "TOP" list(44.25 29.75) "point") list("RIGHT_VDD48_CAP" "V3V3" "TOP" list(45.3 30.35) "point") list("RIGHT_SWCLK_TOP" "SWCLK" "TOP" list(44.25 24.25) "point") list("RIGHT_GPIO_PA15_TOP" "GPIO_PA15" "TOP" list(44.25 24.75) "point") list("RIGHT_SWO_VIA" "SWO" "TOP" list(46.2 25.15) "via") list("RIGHT_SWO_TOP" "SWO" "TOP" list(44.25 25.25) "point") list("RIGHT_SWO_BOTTOM_ANCHOR" "SWO" "BOTTOM" list(46.2 25.15) "point") list("RIGHT_GPIO_PB4_TOP" "GPIO_PB4" "TOP" list(44.25 25.75) "point") list("RIGHT_GPIO_PB5_VIA" "GPIO_PB5" "TOP" list(46.2 26.15) "via") list("RIGHT_GPIO_PB5_TOP" "GPIO_PB5" "TOP" list(44.25 26.25) "point") list("RIGHT_GPIO_PB5_BOTTOM_ANCHOR" "GPIO_PB5" "BOTTOM" list(46.2 26.15) "point") list("RIGHT_I2C_SCL_TOP" "I2C_SCL" "TOP" list(44.25 26.75) "point") list("RIGHT_I2C_SDA_VIA" "I2C_SDA" "TOP" list(46.2 27.15) "via") list("RIGHT_I2C_SDA_TOP" "I2C_SDA" "TOP" list(44.25 27.25) "point") list("RIGHT_I2C_SDA_BOTTOM_ANCHOR" "I2C_SDA" "BOTTOM" list(46.2 27.15) "point") list("RIGHT_BOOT0_TOP" "BOOT0" "TOP" list(44.25 27.75) "point") list("RIGHT_GPIO_PB8_VIA" "GPIO_PB8" "TOP" list(46.2 28.15) "via") list("RIGHT_GPIO_PB8_TOP" "GPIO_PB8" "TOP" list(44.25 28.25) "point") list("RIGHT_GPIO_PB8_BOTTOM_ANCHOR" "GPIO_PB8" "BOTTOM" list(46.2 28.15) "point") list("RIGHT_GPIO_PB9_TOP" "GPIO_PB9" "TOP" list(44.25 28.75) "point") list("RIGHT_R28_GND_RETURN" "GND" "TOP" list(51.3 29.2) "via") list("RIGHT_R28_GND_TOP" "GND" "TOP" list(51.3236 28.0) "point") list("RIGHT_GPIO_PB9_VIA" "GPIO_PB9" "TOP" list(45.7 28.65) "via") list("RIGHT_GPIO_PB9_BOTTOM_ANCHOR" "GPIO_PB9" "BOTTOM" list(45.7 28.65) "point") list("RIGHT_SCL_EXPLICIT" "I2C_SCL" "TOP" list(46.8 26.65) "point") list("RIGHT_SDA_EXPLICIT_BOTTOM" "I2C_SDA" "BOTTOM" list(46.8 27.15) "point") list("RIGHT_SDA_FAR_VIA" "I2C_SDA" "TOP" list(59.2 36.8) "via") list("RIGHT_SDA_FAR_TOP" "I2C_SDA" "TOP" list(59.2 36.8) "point") list("RIGHT_BOOT_DIRECT_TOP" "BOOT0" "TOP" list(46.8 27.65) "point") list("RIGHT_BOOT_R28_J8" "BOOT0" "TOP" list(52.8984 28.0) "point") list("RIGHT_PA15_DIRECT_EAST" "GPIO_PA15" "TOP" list(46.8 24.65) "point") list("RIGHT_PA15_FAR_VIA" "GPIO_PA15" "TOP" list(61.0 24.25) "via") list("RIGHT_PB4_DIRECT_EAST" "GPIO_PB4" "TOP" list(46.8 25.65) "point") list("RIGHT_PB4_FAR_VIA" "GPIO_PB4" "TOP" list(61.8 25.85) "via") list("RIGHT_PB5_BOTTOM_EAST" "GPIO_PB5" "BOTTOM" list(46.8 26.15) "point") list("RIGHT_PB5_MID_VIA" "GPIO_PB5" "TOP" list(56.5 26.55) "via") list("RIGHT_PB5_TOP_EAST" "GPIO_PB5" "TOP" list(56.5 26.55) "point") list("RIGHT_PB5_FAR_VIA" "GPIO_PB5" "TOP" list(62.6 26.55) "via") list("RIGHT_PB8_BOTTOM_EAST" "GPIO_PB8" "BOTTOM" list(46.8 28.15) "point") list("RIGHT_PB8_MID_VIA" "GPIO_PB8" "TOP" list(59.0 27.95) "via") list("RIGHT_PB8_TOP_EAST" "GPIO_PB8" "TOP" list(59.0 27.95) "point") list("RIGHT_PB8_FAR_VIA" "GPIO_PB8" "TOP" list(64.0 27.95) "via") list("RIGHT_PB9_BOTTOM_ESCAPE" "GPIO_PB9" "BOTTOM" list(46.8 28.65) "point") list("RIGHT_PB9_FAR_VIA" "GPIO_PB9" "TOP" list(49.8 31.8) "via") list("RIGHT_SWO_BOTTOM_ESCAPE" "SWO" "BOTTOM" list(46.8 25.15) "point") list("RIGHT_SWO_FAR_VIA" "SWO" "TOP" list(54.0 23.5) "via") list("RIGHT_LONG_GPIO_PA15_0_R0" "GPIO_PA15" "BOTTOM" list(61.0 24.25) "point") list("RIGHT_LONG_GPIO_PB4_0_R0" "GPIO_PB4" "BOTTOM" list(61.8 25.85) "point") list("RIGHT_LONG_GPIO_PB5_0_R0" "GPIO_PB5" "BOTTOM" list(62.6 26.55) "point") list("RIGHT_LONG_GPIO_PB8_0_R0" "GPIO_PB8" "BOTTOM" list(64.0 27.95) "point") list("RIGHT_LONG_GPIO_PB9_0_R0" "GPIO_PB9" "TOP" list(49.8 31.8) "point") list("RIGHT_LONG_SWO_0_R0" "SWO" "TOP" list(54.0 23.5) "point") list("RIGHT_RETURN_RIGHT_SDA_FAR_VIA" "GND" "TOP" list(59.2 37.9) "via") list("RIGHT_RETURN_RIGHT_PA15_FAR_VIA" "GND" "TOP" list(61.0 23.35) "via") list("RIGHT_RETURN_RIGHT_PB4_FAR_VIA" "GND" "TOP" list(61.8 24.95) "via") list("RIGHT_RETURN_RIGHT_PB5_MID_VIA" "GND" "TOP" list(56.757 25.092) "via") list("RIGHT_RETURN_RIGHT_PB5_FAR_VIA" "GND" "TOP" list(62.6 25.65) "via") list("RIGHT_RETURN_RIGHT_PB8_MID_VIA" "GND" "TOP" list(58.55 28.729) "via") list("RIGHT_RETURN_RIGHT_PB8_FAR_VIA" "GND" "TOP" list(63.55 27.171) "via") list("RIGHT_RETURN_RIGHT_SWO_FAR_VIA" "GND" "TOP" list(53.844 22.614) "via") list("HI_2L_I2C_SCL_1_R1" "I2C_SCL" "TOP" list(58.5 35.0) "point") list("HI_2L_I2C_SDA_1_R1" "I2C_SDA" "TOP" list(58.5 37.0) "point") list("RIGHT_SWCLK_TOP_WEST_BRIDGE" "SWCLK" "TOP" list(46.2 24.15) "point") list("RIGHT_SWCLK_WEST_BRIDGE_V" "SWCLK" "TOP" list(47.95 22.4) "via") list("RIGHT_SWCLK_BOTTOM_BRIDGE" "SWCLK" "BOTTOM" list(47.95 22.4) "point") list("RIGHT_SWCLK_EAST_BRIDGE_V" "SWCLK" "TOP" list(57.4 20.8) "via") list("RIGHT_SWCLK_TOP_EAST_BRIDGE" "SWCLK" "TOP" list(57.4 20.8) "point") list("RIGHT_SWCLK_WEST_RETURN" "GND" "TOP" list(46.8 22.5) "via") list("RIGHT_SWCLK_EAST_RETURN" "GND" "TOP" list(57.35 19.31) "via") list("RIGHT_SWCLK_MID_RETURN" "GND" "TOP" list(52.8 22.8) "via") list("HI_4L_BOOT_SERVICE_1_V1" "BOOT_SERVICE" "TOP" list(57.4 33.4) "via") list("HI_4L_BOOT_SERVICE_1_R1" "BOOT_SERVICE" "TOP" list(56.7 32.6764) "point") list("HI_4L_BOOT_SERVICE_1_R2" "BOOT_SERVICE" "BOTTOM" list(57.4 33.4) "point") list("HI_4L_BOOT1_1_V2" "BOOT1" "TOP" list(32.35 23.85) "via") list("HI_4L_BOOT1_1_R3" "BOOT1" "TOP" list(32.35 23.85) "point") list("HI_4L_CAN_TXD_1_V1" "CAN_TXD" "TOP" list(47.7 18.3) "via") list("HI_4L_CAN_TXD_1_V2" "CAN_TXD" "TOP" list(50.25 18.3) "via") list("HI_4L_CAN_TXD_1_R1" "CAN_TXD" "TOP" list(44.4764 18.3) "point") list("HI_4L_CAN_TXD_1_R2" "CAN_TXD" "BOTTOM" list(47.7 18.3) "point") list("HI_4L_CAN_TXD_1_R3" "CAN_TXD" "TOP" list(50.25 18.3) "point") list("LEFT_BOOT1_BOTTOM_RESHAPE" "BOOT1" "BOTTOM" list(34.4 26.0) "point") list("ROOT_SWDIO_BOTTOM" "SWDIO" "BOTTOM" list(41.52 21.25) "point") list("ROOT_SWDIO_EAST_V" "SWDIO" "TOP" list(44.4 21.95) "via") list("ROOT_SWDIO_TOP" "SWDIO" "TOP" list(44.4 21.95) "point") list("ROOT_UART_RX_BOTTOM" "PA10_UART_RX" "BOTTOM" list(40.0 20.5) "point") list("ROOT_UART_RX_EAST_V" "PA10_UART_RX" "TOP" list(50.1 22.4) "via") list("ROOT_UART_RX_TOP" "PA10_UART_RX" "TOP" list(50.1 22.4) "point") list("ROOT_UART_TX_BOTTOM" "PA9_UART_TX" "BOTTOM" list(39.7 21.7) "point") list("ROOT_UART_TX_EAST_V" "PA9_UART_TX" "TOP" list(46.3 21.1) "via") list("ROOT_UART_TX_TOP" "PA9_UART_TX" "TOP" list(46.3 21.1) "point") list("ROOT_ATTACH_BOTTOM" "USB_ATTACH_N" "BOTTOM" list(39.0 21.2) "point") list("ROOT_SWDIO_RETURN_COMMON" "GND" "TOP" list(45.3 22.55) "via") list("NODE_JS_1" "GPIO_PB12" "BOTTOM" list(35.0 21.25) "point") list("NODE_JS_2" "GPIO_PB13" "BOTTOM" list(37.3 19.7) "point") list("NODE_JS_3" "GPIO_PB14" "BOTTOM" list(35.0 22.7) "point") list("NODE_JS_4" "GPIO_PB15" "BOTTOM" list(38.5 22.3) "point") list("NODE_JS_5" "SWCLK" "TOP" list(46.2 24.15) "point") list("NODE_JS_6" "GPIO_PA15" "TOP" list(46.8 24.65) "point") list("NODE_JS_7" "SWO" "BOTTOM" list(46.8 25.15) "point") list("NODE_JS_8" "GPIO_PB4" "TOP" list(46.8 25.65) "point") list("NODE_JS_9" "GPIO_PB5" "BOTTOM" list(46.8 26.15) "point") list("NODE_JS_10" "I2C_SCL" "TOP" list(46.8 26.65) "point") list("NODE_JS_11" "I2C_SDA" "BOTTOM" list(46.8 27.15) "point") list("NODE_JS_12" "BOOT0" "TOP" list(46.8 27.65) "point") list("NODE_JS_13" "GPIO_PB8" "BOTTOM" list(46.8 28.15) "point") list("NODE_JS_14" "GPIO_PB9" "BOTTOM" list(46.8 28.65) "point"))
    hiDiagnosticOutput="D:/001DIY/005lib/01AIEDA/learning/examples/lessonHI_38_50_20261021/logs/source_service_4L_b015_guarded_try09_interactive"
    hiDiagnosticLibrary="D:/001DIY/005lib/01AIEDA/learning/examples/lessonHI_38_50_20261021/library"
    axlSetVariable("padpath" list("D:/001DIY/005lib/01AIEDA/learning/examples/lessonHI_38_50_20261021/library"))
    axlSetVariable("psmpath" list("D:/001DIY/005lib/01AIEDA/learning/examples/lessonHI_38_50_20261021/library"))
    unless(axlLoadPadstack("HI_VIA026_C052_TENT") error("Cannot load isolated concrete via padstack\n"))
    unless(axlLoadPadstack("L28_VIA030_C060") error("Cannot load isolated concrete via padstack\n"))
    hiCSet(f 'physical "HI_JS_P001_4L" "P_SIGNAL_020" list(list('neckwidth_min 0.16) list('necklength_max 2.4) list('vias "L28_VIA030_C060:HI_VIA026_C052_TENT")))
    hiRegion(f "HI_JS_R001_4L" "TOP" list(list(36.6 20.0) list(42.2 20.0) list(42.2 23.4) list(36.6 23.4)) list(list("NC_DIGITAL_GENERAL_P" 'physical "HI_JS_P001_4L" nil)))
    hiCSet(f 'physical "HI_JS_P002_4L" "P_SIGNAL_020" list(list('neckwidth_min 0.16) list('necklength_max 2.4) list('vias "L28_VIA030_C060:HI_VIA026_C052_TENT")))
    hiRegion(f "HI_JS_R002_4L" "BOTTOM" list(list(36.4 19.6) list(39.0 19.6) list(39.0 23.0) list(36.4 23.0)) list(list("NC_DIGITAL_GENERAL_P" 'physical "HI_JS_P002_4L" nil)))
    hiCSet(f 'physical "HI_JS_P003_4L" "P_SIGNAL_020" list(list('neckwidth_min 0.16) list('necklength_max 2.4)))
    hiRegion(f "HI_JS_R003_4L" "BOTTOM" list(list(38.15 20.5) list(38.85 20.5) list(38.85 22.5) list(38.15 22.5)) list(list("NC_DIGITAL_GENERAL_P" 'physical "HI_JS_P003_4L" nil)))
    hiCSet(f 'spacing "HI_JS_S004_4L" "DEFAULT" list(list('line_line 0.16) list('via_line 0.16) list('via_via 0.16)))
    hiRegion(f "HI_JS_R004_4L" "TOP" list(list(36.6 20.0) list(40.55 20.0) list(40.55 23.4) list(36.6 23.4)) list(list("NC_DIGITAL_GENERAL_S" 'spacing "HI_JS_S004_4L" "NC_DIGITAL_GENERAL_S")))
    hiCSet(f 'spacing "HI_JS_S005_4L" "DEFAULT" list(list('line_line 0.16) list('via_line 0.16) list('via_via 0.16)))
    hiRegion(f "HI_JS_R005_4L" "BOTTOM" list(list(36.6 20.0) list(40.55 20.0) list(40.55 23.4) list(36.6 23.4)) list(list("NC_DIGITAL_GENERAL_S" 'spacing "HI_JS_S005_4L" "NC_DIGITAL_GENERAL_S")))
    hiCSet(f 'spacing "HI_JS_S006_4L" "S_USB_OTHER_050" list(list('via_line 0.2) list('line_line 0.2)))
    hiRegion(f "HI_JS_R006_4L" "TOP" list(list(39.65 20.0) list(40.55 20.0) list(40.55 22.15) list(39.65 22.15)) list(list("NC_DIGITAL_GENERAL_S" 'spacing "HI_JS_S006_4L" "NC_USB_FS_S")))
    hiCSet(f 'spacing "HI_JS_S007_4L" "S_USB_OTHER_050" list(list('smdpin_line 0.2) list('line_line 0.2) list('via_line 0.2)))
    hiRegion(f "HI_JS_R007_4L" "TOP" list(list(41.3 21.0) list(42.1 21.0) list(42.1 23.4) list(41.3 23.4)) list(list("NC_DIGITAL_GENERAL_S" 'spacing "HI_JS_S007_4L" "NC_USB_FS_S")))
    hiCSet(f 'spacing "HI_JS_S008_4L" "DEFAULT" list(list('shape_shape 0.3) list('via_shape 0.3) list('via_line 0.2) list('smdpin_line 0.3) list('thrupin_line 0.3) list('line_shape 0.3) list('line_line 0.2) list('via_via 0.2)))
    hiRegion(f "HI_JS_R008_4L" "TOP" list(list(41.2 21.0) list(42.6 21.0) list(42.6 21.8) list(41.2 21.8)) list(list("NC_DIGITAL_GENERAL_S" 'spacing "HI_JS_S008_4L" "NC_POWER_LV_S")))
    hiCSet(f 'spacing "HI_JS_S009_4L" "DEFAULT" list(list('shape_shape 0.3) list('via_shape 0.3) list('via_line 0.2) list('smdpin_line 0.3) list('thrupin_line 0.3) list('line_shape 0.3) list('line_line 0.2) list('via_via 0.2)))
    hiRegion(f "HI_JS_R009_4L" "BOTTOM" list(list(41.2 21.0) list(42.6 21.0) list(42.6 21.8) list(41.2 21.8)) list(list("NC_DIGITAL_GENERAL_S" 'spacing "HI_JS_S009_4L" "NC_POWER_LV_S")))
    hiCSet(f 'spacing "HI_JS_S010_4L" "DEFAULT" list(list('via_line 0.16)))
    hiRegion(f "HI_JS_R010_4L" "BOTTOM" list(list(37.8 20.5) list(39.2 20.5) list(39.2 21.7) list(37.8 21.7)) list(list("NC_DIGITAL_GENERAL_S" 'spacing "HI_JS_S010_4L" "NC_DIGITAL_GENERAL_S")))
    hiCSet(f 'physical "HI_JS_P011_4L" "P_SIGNAL_020" list(list('neckwidth_min 0.16) list('necklength_max 2.8) list('vias "L28_VIA030_C060:HI_VIA026_C052_TENT")))
    hiRegion(f "HI_JS_R011_4L" "TOP" list(list(33.1 24.9) list(36.5 24.9) list(36.5 25.4) list(38.4 25.4) list(38.4 27.4) list(33.1 27.4)) list(list("NC_DIGITAL_GENERAL_P" 'physical "HI_JS_P011_4L" nil)))
    hiCSet(f 'physical "HI_JS_P012_4L" "P_SIGNAL_020" list(list('neckwidth_min 0.16) list('necklength_max 2.8) list('vias "L28_VIA030_C060:HI_VIA026_C052_TENT")))
    hiRegion(f "HI_JS_R012_4L" "TOP" list(list(35.4 26.4) list(38.7 26.4) list(38.7 27.7) list(35.4 27.7)) list(list("NC_DIGITAL_GENERAL_P" 'physical "HI_JS_P012_4L" nil)))
    hiCSet(f 'spacing "HI_JS_S013_4L" "DEFAULT" list(list('shape_shape 0.3) list('via_shape 0.3) list('via_line 0.3) list('smdpin_line 0.2) list('thrupin_line 0.3) list('line_shape 0.3) list('line_line 0.2)))
    hiRegion(f "HI_JS_R013_4L" "TOP" list(list(36.4 25.4) list(37.0 25.4) list(37.0 26.9) list(36.4 26.9)) list(list("NC_DIGITAL_GENERAL_S" 'spacing "HI_JS_S013_4L" "NC_POWER_LV_S")))
    hiCSet(f 'spacing "HI_JS_S014_4L" "DEFAULT" list(list('line_line 0.16) list('via_line 0.16) list('via_via 0.16)))
    hiRegion(f "HI_JS_R014_4L" "TOP" list(list(33.2 25.0) list(35.2 25.0) list(35.2 27.0) list(33.2 27.0)) list(list("NC_DIGITAL_GENERAL_S" 'spacing "HI_JS_S014_4L" "NC_DIGITAL_GENERAL_S")))
    hiCSet(f 'spacing "HI_JS_S015_4L" "DEFAULT" list(list('shape_shape 0.3) list('via_shape 0.3) list('via_line 0.2) list('smdpin_line 0.3) list('thrupin_line 0.3) list('line_shape 0.3) list('line_line 0.3)))
    hiRegion(f "HI_JS_R015_4L" "TOP" list(list(35.4 26.4) list(38.7 26.4) list(38.7 27.7) list(35.4 27.7)) list(list("NC_DIGITAL_GENERAL_S" 'spacing "HI_JS_S015_4L" "NC_POWER_LV_S")))
    hiCSet(f 'physical "HI_JS_P016_4L" "P_SIGNAL_020" list(list('neckwidth_min 0.16) list('necklength_max 2.0) list('vias "L28_VIA030_C060:HI_VIA026_C052_TENT")))
    hiRegion(f "HI_JS_R016_4L" "TOP" list(list(43.5 23.7) list(47.5 23.7) list(47.5 29.0) list(43.5 29.0)) list(list("NC_DIGITAL_GENERAL_P" 'physical "HI_JS_P016_4L" nil)))
    hiCSet(f 'spacing "HI_JS_S017_4L" "DEFAULT" list(list('smdpin_line 0.16) list('line_line 0.16) list('smdpin_via 0.16) list('via_line 0.16) list('via_via 0.16)))
    hiRegion(f "HI_JS_R017_4L" "TOP" list(list(43.5 23.7) list(47.5 23.7) list(47.5 29.0) list(43.5 29.0)) list(list("NC_DIGITAL_GENERAL_S" 'spacing "HI_JS_S017_4L" "NC_DIGITAL_GENERAL_S")))
    hiCSet(f 'physical "HI_JS_P018_4L" "P_SIGNAL_020" list(list('neckwidth_min 0.16) list('necklength_max 2.0) list('vias "L28_VIA030_C060:HI_VIA026_C052_TENT")))
    hiRegion(f "HI_JS_R018_4L" "BOTTOM" list(list(43.5 23.7) list(47.5 23.7) list(47.5 29.0) list(43.5 29.0)) list(list("NC_DIGITAL_GENERAL_P" 'physical "HI_JS_P018_4L" nil)))
    hiCSet(f 'spacing "HI_JS_S019_4L" "DEFAULT" list(list('smdpin_line 0.16) list('line_line 0.16) list('smdpin_via 0.16) list('via_line 0.16) list('via_via 0.16)))
    hiRegion(f "HI_JS_R019_4L" "BOTTOM" list(list(43.5 23.7) list(47.5 23.7) list(47.5 29.0) list(43.5 29.0)) list(list("NC_DIGITAL_GENERAL_S" 'spacing "HI_JS_S019_4L" "NC_DIGITAL_GENERAL_S")))
    hiCSet(f 'physical "HI_JS_P020_4L" "P_SIGNAL_020" list(list('vias "L28_VIA030_C060:HI_VIA026_C052_TENT")))
    hiRegion(f "HI_JS_R020_4L" "L2" list(list(36.99 21.24) list(37.01 21.24) list(37.01 21.26) list(36.99 21.26)) list(list("NC_DIGITAL_GENERAL_P" 'physical "HI_JS_P020_4L" nil)))
    hiCSet(f 'physical "HI_JS_P021_4L" "P_SIGNAL_020" list(list('vias "L28_VIA030_C060:HI_VIA026_C052_TENT")))
    hiRegion(f "HI_JS_R021_4L" "L3" list(list(36.99 21.24) list(37.01 21.24) list(37.01 21.26) list(36.99 21.26)) list(list("NC_DIGITAL_GENERAL_P" 'physical "HI_JS_P021_4L" nil)))
    hiCSet(f 'physical "HI_JS_P022_4L" "P_SIGNAL_020" list(list('vias "L28_VIA030_C060:HI_VIA026_C052_TENT")))
    hiRegion(f "HI_JS_R022_4L" "L2" list(list(37.49 20.74) list(37.51 20.74) list(37.51 20.76) list(37.49 20.76)) list(list("NC_DIGITAL_GENERAL_P" 'physical "HI_JS_P022_4L" nil)))
    hiCSet(f 'physical "HI_JS_P023_4L" "P_SIGNAL_020" list(list('vias "L28_VIA030_C060:HI_VIA026_C052_TENT")))
    hiRegion(f "HI_JS_R023_4L" "L3" list(list(37.49 20.74) list(37.51 20.74) list(37.51 20.76) list(37.49 20.76)) list(list("NC_DIGITAL_GENERAL_P" 'physical "HI_JS_P023_4L" nil)))
    hiCSet(f 'physical "HI_JS_P024_4L" "P_SIGNAL_020" list(list('vias "L28_VIA030_C060:HI_VIA026_C052_TENT")))
    hiRegion(f "HI_JS_R024_4L" "L2" list(list(37.99 21.24) list(38.01 21.24) list(38.01 21.26) list(37.99 21.26)) list(list("NC_DIGITAL_GENERAL_P" 'physical "HI_JS_P024_4L" nil)))
    hiCSet(f 'physical "HI_JS_P025_4L" "P_SIGNAL_020" list(list('vias "L28_VIA030_C060:HI_VIA026_C052_TENT")))
    hiRegion(f "HI_JS_R025_4L" "L3" list(list(37.99 21.24) list(38.01 21.24) list(38.01 21.26) list(37.99 21.26)) list(list("NC_DIGITAL_GENERAL_P" 'physical "HI_JS_P025_4L" nil)))
    hiCSet(f 'physical "HI_JS_P026_4L" "P_SIGNAL_020" list(list('vias "L28_VIA030_C060:HI_VIA026_C052_TENT")))
    hiRegion(f "HI_JS_R026_4L" "L2" list(list(38.49 20.69) list(38.51 20.69) list(38.51 20.71) list(38.49 20.71)) list(list("NC_DIGITAL_GENERAL_P" 'physical "HI_JS_P026_4L" nil)))
    hiCSet(f 'physical "HI_JS_P027_4L" "P_SIGNAL_020" list(list('vias "L28_VIA030_C060:HI_VIA026_C052_TENT")))
    hiRegion(f "HI_JS_R027_4L" "L3" list(list(38.49 20.69) list(38.51 20.69) list(38.51 20.71) list(38.49 20.71)) list(list("NC_DIGITAL_GENERAL_P" 'physical "HI_JS_P027_4L" nil)))
    hiCSet(f 'physical "HI_JS_P028_4L" "P_SIGNAL_020" list(list('vias "L28_VIA030_C060:HI_VIA026_C052_TENT")))
    hiRegion(f "HI_JS_R028_4L" "L2" list(list(38.99 21.19) list(39.01 21.19) list(39.01 21.21) list(38.99 21.21)) list(list("NC_DIGITAL_GENERAL_P" 'physical "HI_JS_P028_4L" nil)))
    hiCSet(f 'physical "HI_JS_P029_4L" "P_SIGNAL_020" list(list('vias "L28_VIA030_C060:HI_VIA026_C052_TENT")))
    hiRegion(f "HI_JS_R029_4L" "L3" list(list(38.99 21.19) list(39.01 21.19) list(39.01 21.21) list(38.99 21.21)) list(list("NC_DIGITAL_GENERAL_P" 'physical "HI_JS_P029_4L" nil)))
    hiCSet(f 'physical "HI_JS_P030_4L" "P_SIGNAL_020" list(list('vias "L28_VIA030_C060:HI_VIA026_C052_TENT")))
    hiRegion(f "HI_JS_R030_4L" "L2" list(list(39.69 21.69) list(39.71 21.69) list(39.71 21.71) list(39.69 21.71)) list(list("NC_DIGITAL_GENERAL_P" 'physical "HI_JS_P030_4L" nil)))
    hiCSet(f 'physical "HI_JS_P031_4L" "P_SIGNAL_020" list(list('vias "L28_VIA030_C060:HI_VIA026_C052_TENT")))
    hiRegion(f "HI_JS_R031_4L" "L3" list(list(39.69 21.69) list(39.71 21.69) list(39.71 21.71) list(39.69 21.71)) list(list("NC_DIGITAL_GENERAL_P" 'physical "HI_JS_P031_4L" nil)))
    hiCSet(f 'physical "HI_JS_P032_4L" "P_SIGNAL_020" list(list('vias "L28_VIA030_C060:HI_VIA026_C052_TENT")))
    hiRegion(f "HI_JS_R032_4L" "BOTTOM" list(list(39.69 21.69) list(39.71 21.69) list(39.71 21.71) list(39.69 21.71)) list(list("NC_DIGITAL_GENERAL_P" 'physical "HI_JS_P032_4L" nil)))
    hiCSet(f 'physical "HI_JS_P033_4L" "P_SIGNAL_020" list(list('vias "L28_VIA030_C060:HI_VIA026_C052_TENT")))
    hiRegion(f "HI_JS_R033_4L" "L2" list(list(39.99 20.49) list(40.01 20.49) list(40.01 20.51) list(39.99 20.51)) list(list("NC_DIGITAL_GENERAL_P" 'physical "HI_JS_P033_4L" nil)))
    hiCSet(f 'physical "HI_JS_P034_4L" "P_SIGNAL_020" list(list('vias "L28_VIA030_C060:HI_VIA026_C052_TENT")))
    hiRegion(f "HI_JS_R034_4L" "L3" list(list(39.99 20.49) list(40.01 20.49) list(40.01 20.51) list(39.99 20.51)) list(list("NC_DIGITAL_GENERAL_P" 'physical "HI_JS_P034_4L" nil)))
    hiCSet(f 'physical "HI_JS_P035_4L" "P_SIGNAL_020" list(list('vias "L28_VIA030_C060:HI_VIA026_C052_TENT")))
    hiRegion(f "HI_JS_R035_4L" "BOTTOM" list(list(39.99 20.49) list(40.01 20.49) list(40.01 20.51) list(39.99 20.51)) list(list("NC_DIGITAL_GENERAL_P" 'physical "HI_JS_P035_4L" nil)))
    hiCSet(f 'physical "HI_JS_P036_4L" "P_GND_PLANE" list(list('vias "L28_VIA030_C060:HI_VIA026_C052_TENT")))
    hiRegion(f "HI_JS_R036_4L" "TOP" list(list(35.79 21.94) list(35.81 21.94) list(35.81 21.96) list(35.79 21.96)) list(list("G31_GND_P" 'physical "HI_JS_P036_4L" nil)))
    hiCSet(f 'physical "HI_JS_P037_4L" "P_GND_PLANE" list(list('vias "L28_VIA030_C060:HI_VIA026_C052_TENT")))
    hiRegion(f "HI_JS_R037_4L" "L2" list(list(35.79 21.94) list(35.81 21.94) list(35.81 21.96) list(35.79 21.96)) list(list("G31_GND_P" 'physical "HI_JS_P037_4L" nil)))
    hiCSet(f 'physical "HI_JS_P038_4L" "P_GND_PLANE" list(list('vias "L28_VIA030_C060:HI_VIA026_C052_TENT")))
    hiRegion(f "HI_JS_R038_4L" "L3" list(list(35.79 21.94) list(35.81 21.94) list(35.81 21.96) list(35.79 21.96)) list(list("G31_GND_P" 'physical "HI_JS_P038_4L" nil)))
    hiCSet(f 'physical "HI_JS_P039_4L" "P_GND_PLANE" list(list('vias "L28_VIA030_C060:HI_VIA026_C052_TENT")))
    hiRegion(f "HI_JS_R039_4L" "BOTTOM" list(list(35.79 21.94) list(35.81 21.94) list(35.81 21.96) list(35.79 21.96)) list(list("G31_GND_P" 'physical "HI_JS_P039_4L" nil)))
    hiCSet(f 'physical "HI_JS_P040_4L" "P_GND_PLANE" list(list('vias "L28_VIA030_C060:HI_VIA026_C052_TENT")))
    hiRegion(f "HI_JS_R040_4L" "TOP" list(list(37.99 19.99) list(38.01 19.99) list(38.01 20.01) list(37.99 20.01)) list(list("G31_GND_P" 'physical "HI_JS_P040_4L" nil)))
    hiCSet(f 'physical "HI_JS_P041_4L" "P_GND_PLANE" list(list('vias "L28_VIA030_C060:HI_VIA026_C052_TENT")))
    hiRegion(f "HI_JS_R041_4L" "L2" list(list(37.99 19.99) list(38.01 19.99) list(38.01 20.01) list(37.99 20.01)) list(list("G31_GND_P" 'physical "HI_JS_P041_4L" nil)))
    hiCSet(f 'physical "HI_JS_P042_4L" "P_GND_PLANE" list(list('vias "L28_VIA030_C060:HI_VIA026_C052_TENT")))
    hiRegion(f "HI_JS_R042_4L" "L3" list(list(37.99 19.99) list(38.01 19.99) list(38.01 20.01) list(37.99 20.01)) list(list("G31_GND_P" 'physical "HI_JS_P042_4L" nil)))
    hiCSet(f 'physical "HI_JS_P043_4L" "P_GND_PLANE" list(list('vias "L28_VIA030_C060:HI_VIA026_C052_TENT")))
    hiRegion(f "HI_JS_R043_4L" "BOTTOM" list(list(37.99 19.99) list(38.01 19.99) list(38.01 20.01) list(37.99 20.01)) list(list("G31_GND_P" 'physical "HI_JS_P043_4L" nil)))
    hiCSet(f 'physical "HI_JS_P044_4L" "P_GND_PLANE" list(list('vias "L28_VIA030_C060:HI_VIA026_C052_TENT")))
    hiRegion(f "HI_JS_R044_4L" "TOP" list(list(38.79 19.69) list(38.81 19.69) list(38.81 19.71) list(38.79 19.71)) list(list("G31_GND_P" 'physical "HI_JS_P044_4L" nil)))
    hiCSet(f 'physical "HI_JS_P045_4L" "P_GND_PLANE" list(list('vias "L28_VIA030_C060:HI_VIA026_C052_TENT")))
    hiRegion(f "HI_JS_R045_4L" "L2" list(list(38.79 19.69) list(38.81 19.69) list(38.81 19.71) list(38.79 19.71)) list(list("G31_GND_P" 'physical "HI_JS_P045_4L" nil)))
    hiCSet(f 'physical "HI_JS_P046_4L" "P_GND_PLANE" list(list('vias "L28_VIA030_C060:HI_VIA026_C052_TENT")))
    hiRegion(f "HI_JS_R046_4L" "L3" list(list(38.79 19.69) list(38.81 19.69) list(38.81 19.71) list(38.79 19.71)) list(list("G31_GND_P" 'physical "HI_JS_P046_4L" nil)))
    hiCSet(f 'physical "HI_JS_P047_4L" "P_GND_PLANE" list(list('vias "L28_VIA030_C060:HI_VIA026_C052_TENT")))
    hiRegion(f "HI_JS_R047_4L" "BOTTOM" list(list(38.79 19.69) list(38.81 19.69) list(38.81 19.71) list(38.79 19.71)) list(list("G31_GND_P" 'physical "HI_JS_P047_4L" nil)))
    hiCSet(f 'physical "HI_JS_P048_4L" "P_SIGNAL_020" list(list('vias "L28_VIA030_C060:HI_VIA026_C052_TENT")))
    hiRegion(f "HI_JS_R048_4L" "L2" list(list(41.51 21.24) list(41.53 21.24) list(41.53 21.26) list(41.51 21.26)) list(list("NC_DIGITAL_GENERAL_P" 'physical "HI_JS_P048_4L" nil)))
    hiCSet(f 'physical "HI_JS_P049_4L" "P_SIGNAL_020" list(list('vias "L28_VIA030_C060:HI_VIA026_C052_TENT")))
    hiRegion(f "HI_JS_R049_4L" "L3" list(list(41.51 21.24) list(41.53 21.24) list(41.53 21.26) list(41.51 21.26)) list(list("NC_DIGITAL_GENERAL_P" 'physical "HI_JS_P049_4L" nil)))
    hiCSet(f 'physical "HI_JS_P050_4L" "P_SIGNAL_020" list(list('vias "L28_VIA030_C060:HI_VIA026_C052_TENT")))
    hiRegion(f "HI_JS_R050_4L" "BOTTOM" list(list(41.51 21.24) list(41.53 21.24) list(41.53 21.26) list(41.51 21.26)) list(list("NC_DIGITAL_GENERAL_P" 'physical "HI_JS_P050_4L" nil)))
    hiCSet(f 'physical "HI_JS_P051_4L" "P_SIGNAL_020" list(list('vias "L28_VIA030_C060:HI_VIA026_C052_TENT")))
    hiRegion(f "HI_JS_R051_4L" "L2" list(list(38.29 27.34) list(38.31 27.34) list(38.31 27.36) list(38.29 27.36)) list(list("NC_DIGITAL_GENERAL_P" 'physical "HI_JS_P051_4L" nil)))
    hiCSet(f 'physical "HI_JS_P052_4L" "P_SIGNAL_020" list(list('vias "L28_VIA030_C060:HI_VIA026_C052_TENT")))
    hiRegion(f "HI_JS_R052_4L" "L3" list(list(38.29 27.34) list(38.31 27.34) list(38.31 27.36) list(38.29 27.36)) list(list("NC_DIGITAL_GENERAL_P" 'physical "HI_JS_P052_4L" nil)))
    hiCSet(f 'physical "HI_JS_P053_4L" "P_SIGNAL_020" list(list('vias "L28_VIA030_C060:HI_VIA026_C052_TENT")))
    hiRegion(f "HI_JS_R053_4L" "BOTTOM" list(list(38.29 27.34) list(38.31 27.34) list(38.31 27.36) list(38.29 27.36)) list(list("NC_DIGITAL_GENERAL_P" 'physical "HI_JS_P053_4L" nil)))
    hiCSet(f 'physical "HI_JS_P054_4L" "P_SIGNAL_020" list(list('vias "L28_VIA030_C060:HI_VIA026_C052_TENT")))
    hiRegion(f "HI_JS_R054_4L" "L2" list(list(37.99 26.39) list(38.01 26.39) list(38.01 26.41) list(37.99 26.41)) list(list("NC_DIGITAL_GENERAL_P" 'physical "HI_JS_P054_4L" nil)))
    hiCSet(f 'physical "HI_JS_P055_4L" "P_SIGNAL_020" list(list('vias "L28_VIA030_C060:HI_VIA026_C052_TENT")))
    hiRegion(f "HI_JS_R055_4L" "L3" list(list(37.99 26.39) list(38.01 26.39) list(38.01 26.41) list(37.99 26.41)) list(list("NC_DIGITAL_GENERAL_P" 'physical "HI_JS_P055_4L" nil)))
    hiCSet(f 'physical "HI_JS_P056_4L" "P_SIGNAL_020" list(list('vias "L28_VIA030_C060:HI_VIA026_C052_TENT")))
    hiRegion(f "HI_JS_R056_4L" "BOTTOM" list(list(37.99 26.39) list(38.01 26.39) list(38.01 26.41) list(37.99 26.41)) list(list("NC_DIGITAL_GENERAL_P" 'physical "HI_JS_P056_4L" nil)))
    hiCSet(f 'physical "HI_JS_P057_4L" "P_SIGNAL_020" list(list('vias "L28_VIA030_C060:HI_VIA026_C052_TENT")))
    hiRegion(f "HI_JS_R057_4L" "L2" list(list(33.69 25.29) list(33.71 25.29) list(33.71 25.31) list(33.69 25.31)) list(list("NC_DIGITAL_GENERAL_P" 'physical "HI_JS_P057_4L" nil)))
    hiCSet(f 'physical "HI_JS_P058_4L" "P_SIGNAL_020" list(list('vias "L28_VIA030_C060:HI_VIA026_C052_TENT")))
    hiRegion(f "HI_JS_R058_4L" "L3" list(list(33.69 25.29) list(33.71 25.29) list(33.71 25.31) list(33.69 25.31)) list(list("NC_DIGITAL_GENERAL_P" 'physical "HI_JS_P058_4L" nil)))
    hiCSet(f 'physical "HI_JS_P059_4L" "P_SIGNAL_020" list(list('vias "L28_VIA030_C060:HI_VIA026_C052_TENT")))
    hiRegion(f "HI_JS_R059_4L" "BOTTOM" list(list(33.69 25.29) list(33.71 25.29) list(33.71 25.31) list(33.69 25.31)) list(list("NC_DIGITAL_GENERAL_P" 'physical "HI_JS_P059_4L" nil)))
    hiCSet(f 'physical "HI_JS_P060_4L" "P_SIGNAL_020" list(list('vias "L28_VIA030_C060:HI_VIA026_C052_TENT")))
    hiRegion(f "HI_JS_R060_4L" "L2" list(list(34.39 25.99) list(34.41 25.99) list(34.41 26.01) list(34.39 26.01)) list(list("NC_DIGITAL_GENERAL_P" 'physical "HI_JS_P060_4L" nil)))
    hiCSet(f 'physical "HI_JS_P061_4L" "P_SIGNAL_020" list(list('vias "L28_VIA030_C060:HI_VIA026_C052_TENT")))
    hiRegion(f "HI_JS_R061_4L" "L3" list(list(34.39 25.99) list(34.41 25.99) list(34.41 26.01) list(34.39 26.01)) list(list("NC_DIGITAL_GENERAL_P" 'physical "HI_JS_P061_4L" nil)))
    hiCSet(f 'physical "HI_JS_P062_4L" "P_SIGNAL_020" list(list('vias "L28_VIA030_C060:HI_VIA026_C052_TENT")))
    hiRegion(f "HI_JS_R062_4L" "BOTTOM" list(list(34.39 25.99) list(34.41 25.99) list(34.41 26.01) list(34.39 26.01)) list(list("NC_DIGITAL_GENERAL_P" 'physical "HI_JS_P062_4L" nil)))
    hiCSet(f 'physical "HI_JS_P063_4L" "P_SIGNAL_020" list(list('vias "L28_VIA030_C060:HI_VIA026_C052_TENT")))
    hiRegion(f "HI_JS_R063_4L" "L2" list(list(34.59 26.84) list(34.61 26.84) list(34.61 26.86) list(34.59 26.86)) list(list("NC_DIGITAL_GENERAL_P" 'physical "HI_JS_P063_4L" nil)))
    hiCSet(f 'physical "HI_JS_P064_4L" "P_SIGNAL_020" list(list('vias "L28_VIA030_C060:HI_VIA026_C052_TENT")))
    hiRegion(f "HI_JS_R064_4L" "L3" list(list(34.59 26.84) list(34.61 26.84) list(34.61 26.86) list(34.59 26.86)) list(list("NC_DIGITAL_GENERAL_P" 'physical "HI_JS_P064_4L" nil)))
    hiCSet(f 'physical "HI_JS_P065_4L" "P_SIGNAL_020" list(list('vias "L28_VIA030_C060:HI_VIA026_C052_TENT")))
    hiRegion(f "HI_JS_R065_4L" "BOTTOM" list(list(34.59 26.84) list(34.61 26.84) list(34.61 26.86) list(34.59 26.86)) list(list("NC_DIGITAL_GENERAL_P" 'physical "HI_JS_P065_4L" nil)))
    hiCSet(f 'physical "HI_JS_P066_4L" "P_SIGNAL_020" list(list('vias "L28_VIA030_C060:HI_VIA026_C052_TENT")))
    hiRegion(f "HI_JS_R066_4L" "L2" list(list(46.19 25.14) list(46.21 25.14) list(46.21 25.16) list(46.19 25.16)) list(list("NC_DIGITAL_GENERAL_P" 'physical "HI_JS_P066_4L" nil)))
    hiCSet(f 'physical "HI_JS_P067_4L" "P_SIGNAL_020" list(list('vias "L28_VIA030_C060:HI_VIA026_C052_TENT")))
    hiRegion(f "HI_JS_R067_4L" "L3" list(list(46.19 25.14) list(46.21 25.14) list(46.21 25.16) list(46.19 25.16)) list(list("NC_DIGITAL_GENERAL_P" 'physical "HI_JS_P067_4L" nil)))
    hiCSet(f 'physical "HI_JS_P068_4L" "P_SIGNAL_020" list(list('vias "L28_VIA030_C060:HI_VIA026_C052_TENT")))
    hiRegion(f "HI_JS_R068_4L" "L2" list(list(46.19 26.14) list(46.21 26.14) list(46.21 26.16) list(46.19 26.16)) list(list("NC_DIGITAL_GENERAL_P" 'physical "HI_JS_P068_4L" nil)))
    hiCSet(f 'physical "HI_JS_P069_4L" "P_SIGNAL_020" list(list('vias "L28_VIA030_C060:HI_VIA026_C052_TENT")))
    hiRegion(f "HI_JS_R069_4L" "L3" list(list(46.19 26.14) list(46.21 26.14) list(46.21 26.16) list(46.19 26.16)) list(list("NC_DIGITAL_GENERAL_P" 'physical "HI_JS_P069_4L" nil)))
    hiCSet(f 'physical "HI_JS_P070_4L" "P_SIGNAL_020" list(list('vias "L28_VIA030_C060:HI_VIA026_C052_TENT")))
    hiRegion(f "HI_JS_R070_4L" "L2" list(list(46.19 27.14) list(46.21 27.14) list(46.21 27.16) list(46.19 27.16)) list(list("NC_DIGITAL_GENERAL_P" 'physical "HI_JS_P070_4L" nil)))
    hiCSet(f 'physical "HI_JS_P071_4L" "P_SIGNAL_020" list(list('vias "L28_VIA030_C060:HI_VIA026_C052_TENT")))
    hiRegion(f "HI_JS_R071_4L" "L3" list(list(46.19 27.14) list(46.21 27.14) list(46.21 27.16) list(46.19 27.16)) list(list("NC_DIGITAL_GENERAL_P" 'physical "HI_JS_P071_4L" nil)))
    hiCSet(f 'physical "HI_JS_P072_4L" "P_SIGNAL_020" list(list('vias "L28_VIA030_C060:HI_VIA026_C052_TENT")))
    hiRegion(f "HI_JS_R072_4L" "L2" list(list(46.19 28.14) list(46.21 28.14) list(46.21 28.16) list(46.19 28.16)) list(list("NC_DIGITAL_GENERAL_P" 'physical "HI_JS_P072_4L" nil)))
    hiCSet(f 'physical "HI_JS_P073_4L" "P_SIGNAL_020" list(list('vias "L28_VIA030_C060:HI_VIA026_C052_TENT")))
    hiRegion(f "HI_JS_R073_4L" "L3" list(list(46.19 28.14) list(46.21 28.14) list(46.21 28.16) list(46.19 28.16)) list(list("NC_DIGITAL_GENERAL_P" 'physical "HI_JS_P073_4L" nil)))
    hiCSet(f 'physical "HI_JS_P074_4L" "P_SIGNAL_020" list(list('vias "L28_VIA030_C060:HI_VIA026_C052_TENT")))
    hiRegion(f "HI_JS_R074_4L" "L2" list(list(45.69 28.64) list(45.71 28.64) list(45.71 28.66) list(45.69 28.66)) list(list("NC_DIGITAL_GENERAL_P" 'physical "HI_JS_P074_4L" nil)))
    hiCSet(f 'physical "HI_JS_P075_4L" "P_SIGNAL_020" list(list('vias "L28_VIA030_C060:HI_VIA026_C052_TENT")))
    hiRegion(f "HI_JS_R075_4L" "L3" list(list(45.69 28.64) list(45.71 28.64) list(45.71 28.66) list(45.69 28.66)) list(list("NC_DIGITAL_GENERAL_P" 'physical "HI_JS_P075_4L" nil)))
    hiSpacingLayerFieldsUpdate(f "HI_USB_MCU_S_1_4L" list(list("TOP" 'via_line "0.2 MM") list("BOTTOM" 'via_line "0.2 MM")))
    hiDeleteExactBatch(f list(list("deleteVia" "NSS01_DEL_VIA_[39, 26.2]" "PA4_SPI_NSS" "" list(39.0 26.2) "L28_VIA030_C060") list("deleteVia" "NSS01_DEL_VIA_[32.2, 22]" "PA4_SPI_NSS" "" list(32.2 22.0) "L28_VIA030_C060") list("deleteVia" "OLD_PC14" "GPIO_PC14" "" list(45.6 25.2) "L28_VIA030_C060") list("deleteVia" "OLD_PC14_GND" "GND" "" list(46.95 24.9) "L28_VIA030_C060") list("deleteVia" "OLD_HSE_ANCHOR" "GND" "" list(45.45 28.85) "L28_VIA030_C060") list("deleteVia" "OLD_C15_COMMON_GND" "GND" "" list(47.45 28.7252) "L28_VIA030_C060") list("deleteSegment" "GPIO_NORTH_RIP_PC15_VERTICAL" "GPIO_PC15" "BOTTOM" list(list(40.3 28.9) list(40.3 30.3)) 0.2) list("deleteSegment" "GPIO_NORTH_RIP_PC15_WEST" "GPIO_PC15" "BOTTOM" list(list(40.3 30.3) list(35.4 30.3)) 0.2) list("deleteSegment" "SOUTH_RIP_C14_GND_0" "GND" "TOP" list(list(42.25 22.75) list(42.25 21.95)) 0.25) list("deleteSegment" "SOUTH_RIP_C14_GND_1" "GND" "TOP" list(list(42.25 21.95) list(41.85 21.55)) 0.25) list("deleteSegment" "SOUTH_RIP_C14_GND_2" "GND" "TOP" list(list(41.85 21.55) list(42.3252 21.0748)) 0.6) list("deleteSegment" "SOUTH_RIP_C14_GND_3" "GND" "TOP" list(list(42.3252 21.0748) list(42.3252 20.3)) 0.6) list("deleteSegment" "LEFT_RIP_0" "GND" "TOP" list(list(35.75 24.75) list(34.95 24.75)) 0.25) list("deleteSegment" "LEFT_RIP_1" "GND" "TOP" list(list(34.95 24.75) list(34.55 25.15)) 0.25) list("deleteSegment" "LEFT_RIP_2" "GND" "TOP" list(list(34.55 25.15) list(33.4 25.2748)) 0.6) list("deleteSegment" "LEFT_RIP_3" "GND" "TOP" list(list(33.4 25.2748) list(32.45 25.2748)) 0.6) list("deleteSegment" "LEFT_RIP_4" "V3V3" "TOP" list(list(35.75 24.25) list(34.95 24.25)) 0.25) list("deleteSegment" "LEFT_RIP_5" "V3V3" "TOP" list(list(34.95 24.25) list(34.55 23.85)) 0.25) list("deleteSegment" "LEFT_RIP_6" "V3V3" "TOP" list(list(34.55 23.85) list(33.4 23.7)) 0.6) list("deleteSegment" "LEFT_RIP_7" "V3V3" "TOP" list(list(33.3 22.5) list(33.3 24.0)) 0.6) list("deleteSegment" "LEFT_RIP_8" "V3V3" "TOP" list(list(33.3 24.0) list(37.0 24.0)) 0.6) list("deleteSegment" "NSS01_DEL_0" "PA4_SPI_NSS" "TOP" list(list(35.75 29.25) list(36.8 29.25)) 0.2) list("deleteSegment" "NSS01_DEL_1" "PA4_SPI_NSS" "TOP" list(list(36.8 29.25) list(39.0 27.05)) 0.2) list("deleteSegment" "NSS01_DEL_2" "PA4_SPI_NSS" "TOP" list(list(39.0 27.05) list(39.0 26.2)) 0.2) list("deleteSegment" "NSS01_DEL_3" "PA4_SPI_NSS" "BOTTOM" list(list(39.0 26.2) list(39.0 21.3)) 0.2) list("deleteSegment" "NSS01_DEL_4" "PA4_SPI_NSS" "BOTTOM" list(list(39.0 21.3) list(32.2 21.3)) 0.2) list("deleteSegment" "NSS01_DEL_5" "PA4_SPI_NSS" "BOTTOM" list(list(32.2 21.3) list(32.2 22.0)) 0.2) list("deleteSegment" "NSS01_DEL_6" "PA4_SPI_NSS" "TOP" list(list(32.2 22.0) list(32.0 21.0)) 0.2) list("deleteSegment" "NSS01_DEL_9" "PA4_SPI_NSS" "TOP" list(list(32.93 33.02) list(32.7984 33.02)) 0.2) list("deleteSegment" "NSS01_DEL_10" "PA4_SPI_NSS" "TOP" list(list(34.8 31.15) list(32.93 33.02)) 0.2) list("deleteSegment" "NSS01_DEL_13" "PA5_SPI_SCK" "TOP" list(list(34.385 30.215) list(33.6 31.0)) 0.2) list("deleteSegment" "NSS01_DEL_15" "ADC0" "TOP" list(list(32.8 35.0) list(32.6764 35.0)) 0.2) list("deleteSegment" "NSS01_DEL_16" "ADC0" "TOP" list(list(34.8 33.0) list(32.8 35.0)) 0.2) list("deleteSegment" "NSS01_DEL_17" "ADC_IN" "TOP" list(list(29.8 34.0) list(26.27 34.0)) 0.2) list("deleteSegment" "NSS01_DEL_18" "ADC_IN" "TOP" list(list(30.8 35.0) list(29.8 34.0)) 0.2) list("deleteSegment" "NSS01_DEL_19" "ADC_IN" "TOP" list(list(31.1016 35.0) list(30.8 35.0)) 0.2) list("deleteSegment" "NSS01_4L_DEL_0" "SPI_SCK" "TOP" list(list(32.05 31.0) list(31.0 29.95)) 0.2) list("deleteSegment" "NSS01_4L_DEL_1" "SPI_SCK" "TOP" list(list(32.0252 31.0) list(32.05 31.0)) 0.2) list("deleteSegment" "NSS01_4L_DEL_3" "SPI_NSS" "TOP" list(list(30.5 33.0) list(29.8 32.3)) 0.2) list("deleteSegment" "NSS01_4L_DEL_4" "SPI_NSS" "TOP" list(list(31.2 33.0) list(30.5 33.0)) 0.2) list("deleteSegment" "NSS01_4L_DEL_5" "SPI_NSS" "TOP" list(list(31.2236 33.02) list(31.2 33.0)) 0.2) list("deleteSegment" "RIGHT_RIP_0" "GND" "TOP" list(list(45.05 29.25) list(45.45 28.85)) 0.25) list("deleteSegment" "RIGHT_RIP_1" "GND" "TOP" list(list(44.25 29.25) list(45.05 29.25)) 0.25) list("deleteSegment" "RIGHT_RIP_2" "GND" "TOP" list(list(45.45 28.85) list(46.5 28.7252)) 0.6) list("deleteSegment" "RIGHT_RIP_3" "GND" "TOP" list(list(46.5 28.7252) list(47.45 28.7252)) 0.6) list("deleteSegment" "RIGHT_RIP_4" "GND" "TOP" list(list(47.9428 28.7252) list(47.45 28.7252)) 0.6) list("deleteSegment" "RIGHT_RIP_5" "GND" "TOP" list(list(48.4 28.268) list(47.9428 28.7252)) 0.6) list("deleteSegment" "RIGHT_RIP_6" "GND" "TOP" list(list(49.5 28.268) list(48.4 28.268)) 0.6) list("deleteSegment" "RIGHT_RIP_7" "V3V3" "TOP" list(list(45.45 30.15) list(46.5 30.3)) 0.6) list("deleteSegment" "RIGHT_RIP_8" "V3V3" "TOP" list(list(45.05 29.75) list(45.45 30.15)) 0.25) list("deleteSegment" "RIGHT_RIP_9" "V3V3" "TOP" list(list(44.25 29.75) list(45.05 29.75)) 0.25) list("deleteSegment" "RIGHT_RIP_10" "V3V3" "TOP" list(list(49.5 30.3) list(46.5 30.3)) 0.6) list("deleteSegment" "RIGHT_RIP_11" "GPIO_PC14" "BOTTOM" list(list(43.6 25.2) list(45.6 25.2)) 0.2)))
    hiMove(f "R16" list(45.5 19.9) 0.0)
    hiMove(f "C13" list(34.0 22.4984) 90.0)
    hiMove(f "R21" list(33.7016 30.7) 180.0)
    hiMove(f "R23" list(33.5 32.1) 180.0)
    hiMove(f "R25" list(31.0 33.7) 0.0)
    hiMove(f "R32" list(31.0 35.5) 0.0)
    hiMove(f "C15" list(47.3 30.4016) 270.0)
    hiMove(f "R28" list(53.0 28.0) 180.0)
    hiReplaceExactShape(f "HI_HSE_QUIET_REPLACE" "GND" "L2" list(list(45.1 28.5) list(45.8 28.5) list(45.8 31.25) list(45.1 31.95) list(45.3 31.95) list(45.3 33.2) list(47.5 33.2) list(47.5 39.4) list(37.2 39.4) list(37.2 36.8) list(40.0 36.8) list(40.0 32.8) list(40.6 32.8) list(40.6 31.95) list(44.4 31.95) list(45.1 31.25)) list(list(46.0 29.3) list(46.7 29.3) list(46.7 31.25) list(46.2 31.75) list(46.2 33.2) list(47.5 33.2) list(47.5 39.4) list(37.2 39.4) list(37.2 36.8) list(40.0 36.8) list(40.0 32.8) list(40.6 32.8) list(40.6 31.95) list(45.3 31.95) list(46.0 31.25)) nil list())
    hiReplaceExactVoid(f "HI_HSE_MOAT_REPLACE_L2" "GND" "L2" list(list(0.5 0.5) list(79.5 59.5)) list(list(44.75 28.15) list(46.15 28.15) list(46.15 31.4) list(45.65 31.9) list(45.65 32.85) list(47.85 32.85) list(47.85 39.75) list(36.85 39.75) list(36.85 36.45) list(39.65 36.45) list(39.65 32.45) list(40.25 32.45) list(40.25 31.6) list(44.25 31.6) list(44.75 31.1)) list(list(45.65 28.95) list(45.65 31.10502525316942) list(45.15502525316942 31.599999999999998) list(40.25 31.599999999999998) list(40.25 32.449999999999996) list(39.65 32.449999999999996) list(39.65 36.449999999999996) list(36.85 36.449999999999996) list(36.85 39.75) list(47.85 39.75) list(47.85 32.85) list(46.550000000000004 32.85) list(46.550000000000004 31.89497474683058) list(47.050000000000004 31.39497474683058) list(47.050000000000004 28.95)))
    hiReplaceExactVoid(f "HI_HSE_MOAT_REPLACE_L3" "GND" "L3" list(list(0.5 0.5) list(79.5 59.5)) list(list(44.75 28.15) list(46.15 28.15) list(46.15 31.4) list(45.65 31.9) list(45.65 32.85) list(47.85 32.85) list(47.85 39.75) list(36.85 39.75) list(36.85 36.45) list(39.65 36.45) list(39.65 32.45) list(40.25 32.45) list(40.25 31.6) list(44.25 31.6) list(44.75 31.1)) list(list(45.65 28.95) list(45.65 31.10502525316942) list(45.15502525316942 31.599999999999998) list(40.25 31.599999999999998) list(40.25 32.449999999999996) list(39.65 32.449999999999996) list(39.65 36.449999999999996) list(36.85 36.449999999999996) list(36.85 39.75) list(47.85 39.75) list(47.85 32.85) list(46.550000000000004 32.85) list(46.550000000000004 31.89497474683058) list(47.050000000000004 31.39497474683058) list(47.050000000000004 28.95)))
    hiRoute(f "GPIO_NORTH_PC15_DIRECT_WEST" "GPIO_PC15" "BOTTOM" list(list(40.3 28.9) list(35.4 28.9)) list(0.2))
    hiRoute(f "GPIO_PA1_INWARD_FANOUT" "GPIO_PA1" "TOP" list(list(37.75 31.25) list(37.75 30.0) list(37.5 29.75) list(37.5 29.6)) list(0.2 0.2 0.2))
    hiVia(f "GPIO_PA1_INWARD_VIA" "GPIO_PA1" list(37.5 29.6) "L28_VIA030_C060")
    hiRoute(f "GPIO_PA2_INWARD_FANOUT" "GPIO_PA2" "TOP" list(list(37.25 31.25) list(37.25 31.05) list(36.6 30.4)) list(0.2 0.2))
    hiVia(f "GPIO_PA2_INWARD_VIA" "GPIO_PA2" list(36.6 30.4) "L28_VIA030_C060")
    hiRoute(f "GPIO_PA3_INWARD_FANOUT" "GPIO_PA3" "TOP" list(list(35.75 29.75) list(35.75 31.1) list(35.2 31.65)) list(0.2 0.2))
    hiVia(f "GPIO_PA3_INWARD_VIA" "GPIO_PA3" list(35.2 31.65) "L28_VIA030_C060")
    hiVia(f "GPIO_NORTH_COMMON_RETURN" "GND" list(39.5 28.0) "L28_VIA030_C060")
    hiRoute(f "SOUTH_SOURCE_25_NECK" "GPIO_PB12" "TOP" list(list(37.25 22.75) list(37.25 22.1) list(37.0 21.85) list(37.0 21.25)) list(0.16 0.16 0.16))
    hiVia(f "SOUTH_SOURCE_25_VIA" "GPIO_PB12" list(37.0 21.25) "HI_VIA026_C052_TENT")
    hiRoute(f "SOUTH_SOURCE_26_NECK" "GPIO_PB13" "TOP" list(list(37.75 22.75) list(37.75 22.1) list(37.5 21.85) list(37.5 20.75)) list(0.16 0.16 0.16))
    hiVia(f "SOUTH_SOURCE_26_VIA" "GPIO_PB13" list(37.5 20.75) "HI_VIA026_C052_TENT")
    hiRoute(f "SOUTH_SOURCE_27_NECK" "GPIO_PB14" "TOP" list(list(38.25 22.75) list(38.25 22.1) list(38.0 21.85) list(38.0 21.25)) list(0.16 0.16 0.16))
    hiVia(f "SOUTH_SOURCE_27_VIA" "GPIO_PB14" list(38.0 21.25) "HI_VIA026_C052_TENT")
    hiRoute(f "SOUTH_SOURCE_28_NECK" "GPIO_PB15" "TOP" list(list(38.75 22.75) list(38.75 22.1) list(38.5 21.85) list(38.5 20.7)) list(0.16 0.16 0.16))
    hiVia(f "SOUTH_SOURCE_28_VIA" "GPIO_PB15" list(38.5 20.7) "HI_VIA026_C052_TENT")
    hiRoute(f "SOUTH_SOURCE_29_NECK" "USB_ATTACH_N" "TOP" list(list(39.25 22.75) list(39.25 22.1) list(39.0 21.85) list(39.0 21.2)) list(0.16 0.16 0.16))
    hiVia(f "SOUTH_SOURCE_29_VIA" "USB_ATTACH_N" list(39.0 21.2) "HI_VIA026_C052_TENT")
    hiRoute(f "SOUTH_SOURCE_30_NECK" "PA9_UART_TX" "TOP" list(list(39.75 22.75) list(39.75 21.75) list(39.7 21.7)) list(0.16 0.16))
    hiVia(f "SOUTH_SOURCE_30_VIA" "PA9_UART_TX" list(39.7 21.7) "HI_VIA026_C052_TENT")
    hiRoute(f "SOUTH_SOURCE_31_NECK" "PA10_UART_RX" "TOP" list(list(40.25 22.75) list(40.25 22.05) list(40.22 22.02) list(40.22 21.3) list(40.0 21.08) list(40.0 20.5)) list(0.16 0.16 0.16 0.16 0.16))
    hiVia(f "SOUTH_SOURCE_31_VIA" "PA10_UART_RX" list(40.0 20.5) "HI_VIA026_C052_TENT")
    hiVia(f "SOUTH_RETURN_WEST" "GND" list(35.8 21.95) "HI_VIA026_C052_TENT")
    hiVia(f "SOUTH_RETURN_MID" "GND" list(38.0 20.0) "HI_VIA026_C052_TENT")
    hiVia(f "SOUTH_RETURN_EAST" "GND" list(38.8 19.7) "HI_VIA026_C052_TENT")
    hiRoute(f "SOUTH_SOURCE_34_NECK" "SWDIO" "TOP" list(list(41.75 22.75) list(41.75 21.7) list(41.52 21.47) list(41.52 21.25)) list(0.16 0.16 0.16))
    hiVia(f "SOUTH_SOURCE_34_VIA" "SWDIO" list(41.52 21.25) "HI_VIA026_C052_TENT")
    hiRoute(f "SOUTH_C14_GND_NECK" "GND" "TOP" list(list(42.25 22.75) list(42.25 21.4) list(42.28 21.37)) list(0.25 0.25))
    hiRoute(f "SOUTH_C14_GND_WIDE" "GND" "TOP" list(list(42.28 21.37) list(42.3252 21.3248) list(42.3252 20.3)) list(0.6 0.6))
    hiRoute(f "SOUTH_GPIO12_BOTTOM_NECK" "GPIO_PB12" "BOTTOM" list(list(37.0 21.25) list(36.5 21.25)) list(0.16))
    hiRoute(f "SOUTH_GPIO12_BOTTOM_EXIT" "GPIO_PB12" "BOTTOM" list(list(36.5 21.25) list(35.0 21.25)) list(0.2))
    hiRoute(f "SOUTH_GPIO13_BOTTOM_NECK" "GPIO_PB13" "BOTTOM" list(list(37.5 20.75) list(37.3 20.55) list(37.3 19.7)) list(0.16 0.16))
    hiRoute(f "SOUTH_GPIO14_BOTTOM_NECK" "GPIO_PB14" "BOTTOM" list(list(38.0 21.25) list(38.0 21.9)) list(0.16))
    hiRoute(f "SOUTH_GPIO14_BOTTOM_EXIT" "GPIO_PB14" "BOTTOM" list(list(38.0 21.9) list(38.0 22.7) list(35.0 22.7)) list(0.2 0.2))
    hiRoute(f "SOUTH_GPIO15_BOTTOM_NECK" "GPIO_PB15" "BOTTOM" list(list(38.5 20.7) list(38.5 22.3)) list(0.16))
    hiRoute(f "LEFT_C13_VDD24_NECK" "V3V3" "TOP" list(list(35.75 24.25) list(35.1 23.6) list(35.1 23.2)) list(0.25 0.25))
    hiRoute(f "LEFT_C13_VDD24_WIDE" "V3V3" "TOP" list(list(35.1 23.2) list(34.5 22.6) list(34.0 22.6)) list(0.6 0.6))
    hiRoute(f "LEFT_C13_VSS23_NECK" "GND" "TOP" list(list(35.75 24.75) list(34.7 24.75)) list(0.25))
    hiRoute(f "LEFT_C13_VSS23_WIDE" "GND" "TOP" list(list(34.7 24.75) list(34.0 24.05) list(34.0 24.1748)) list(0.6 0.6))
    hiRoute(f "LEFT_C13_COMMON_RETURN" "GND" "TOP" list(list(34.0 24.1748) list(33.55 24.1748) list(32.45 25.2748)) list(0.6 0.6))
    hiRoute(f "LEFT_V3_PERIPHERAL_REROUTE" "V3V3" "TOP" list(list(33.3 22.5) list(34.8 22.5) list(36.0 23.7) list(37.0 24.0)) list(0.6 0.6 0.6))
    hiRoute(f "LEFT_SOURCE_19_NECK" "GPIO_PB1" "TOP" list(list(35.75 26.75) list(37.4 26.75) list(37.9 26.95) list(38.3 27.35)) list(0.16 0.16 0.16))
    hiVia(f "LEFT_SOURCE_19_VIA" "GPIO_PB1" list(38.3 27.35) "HI_VIA026_C052_TENT")
    hiRoute(f "LEFT_SOURCE_21_NECK" "GPIO_PB10" "TOP" list(list(35.75 25.75) list(36.65 25.75) list(37.3 26.4) list(38.0 26.4)) list(0.16 0.16 0.16))
    hiVia(f "LEFT_SOURCE_21_VIA" "GPIO_PB10" list(38.0 26.4) "HI_VIA026_C052_TENT")
    hiRoute(f "LEFT_SOURCE_22_NECK" "GPIO_PB11" "TOP" list(list(35.75 25.25) list(35.0 25.25) list(34.75 25.5) list(33.7 25.5) list(33.7 25.3)) list(0.16 0.16 0.16 0.16))
    hiVia(f "LEFT_SOURCE_22_VIA" "GPIO_PB11" list(33.7 25.3) "HI_VIA026_C052_TENT")
    hiRoute(f "LEFT_BOOT1_SOURCE_NECK" "BOOT1" "TOP" list(list(35.75 26.25) list(35.1 26.25) list(34.85 26.0) list(34.4 26.0)) list(0.16 0.16 0.16))
    hiVia(f "LEFT_BOOT1_SOURCE_VIA" "BOOT1" list(34.4 26.0) "HI_VIA026_C052_TENT")
    hiRoute(f "LEFT07_VBUS18_SOURCE" "VBUS_PRESENT_N" "TOP" list(list(35.75 27.25) list(35.0 27.25) list(34.6 26.85)) list(0.16 0.16))
    hiVia(f "LEFT07_VBUS18_VIA" "VBUS_PRESENT_N" list(34.6 26.85) "HI_VIA026_C052_TENT")
    hiRoute(f "NSS01_MAIN_SOURCE" "PA4_SPI_NSS" "TOP" list(list(34.8 31.15) list(33.85 32.1) list(33.3984 32.1)) list(0.2 0.2))
    hiRoute(f "NSS01_LOCAL_PULLUP_STUB" "PA4_SPI_NSS" "TOP" list(list(33.3984 32.1) list(33.3984 32.9) list(32.6764 33.622) list(32.6764 33.7)) list(0.2 0.2 0.2))
    hiRoute(f "NSS01_SCK_SOURCE" "PA5_SPI_SCK" "TOP" list(list(34.385 30.215) list(33.9 30.7) list(33.6 30.7)) list(0.2 0.2))
    hiRoute(f "NSS01_ADC_SERIES_TO_LOCAL_CAP" "ADC0" "TOP" list(list(34.8 33.0) list(34.5 33.0) list(33.65 33.85) list(33.65 35.5) list(32.6764 35.5)) list(0.2 0.2 0.2 0.2))
    hiRoute(f "NSS01_ADC_INPUT" "ADC_IN" "TOP" list(list(31.1016 35.5) list(30.8 35.5) list(29.3 34.0) list(26.27 34.0)) list(0.2 0.2 0.2))
    hiVia(f "NSS01_R25_SUPPLY_VIA" "V3V3" list(30.4 33.7) "L28_VIA030_C060")
    hiRoute(f "NSS01_R25_SUPPLY_BOTTOM" "V3V3" "BOTTOM" list(list(30.7 32.0) list(31.0 32.3) list(31.0 33.7) list(30.4 33.7)) list(0.6 0.6 0.6))
    hiRoute(f "NSS01_R25_SUPPLY_TOP" "V3V3" "TOP" list(list(30.4 33.7) list(31.1016 33.7)) list(0.6))
    hiRoute(f "NSS01_4L_ADD_2" "SPI_SCK" "TOP" list(list(32.0252 30.7) list(31.75 30.7) list(31.0 29.95)) list(0.2 0.2))
    hiRoute(f "NSS01_4L_ADD_6" "SPI_NSS" "TOP" list(list(31.8236 32.1) list(31.8236 32.2) list(31.2236 32.8) list(30.3 32.8) list(29.8 32.3)) list(0.2 0.2 0.2 0.2))
    hiRoute(f "RIGHT_PC14_SOUTH_BYPASS" "GPIO_PC14" "BOTTOM" list(list(43.6 25.2) list(44.2 24.6) list(44.2 23.7) list(49.2 23.7) list(49.2 25.2)) list(0.2 0.2 0.2 0.2))
    hiVia(f "RIGHT_PC14_FINAL" "GPIO_PC14" list(49.2 25.2) "L28_VIA030_C060")
    hiVia(f "RIGHT_PC14_RETURN" "GND" list(48.2 25.0) "L28_VIA030_C060")
    hiRoute(f "RIGHT_VSS47_NECK" "GND" "TOP" list(list(44.25 29.25) list(45.05 29.25) list(45.3 29.5) list(45.4 29.5)) list(0.25 0.25 0.25))
    hiRoute(f "RIGHT_VSS47_CAP_GROUND" "GND" "TOP" list(list(45.4 29.5) list(45.7 29.5) list(46.35 29.4) list(47.0248 28.7252) list(47.3 28.7252) list(48.25 28.7252) list(48.7072 28.268) list(49.5 28.268)) list(0.6 0.6 0.6 0.6 0.6 0.6 0.6))
    hiVia(f "HSE_SINGLE_ANCHOR_REWORK" "GND" list(46.35 29.4) "L28_VIA030_C060")
    hiVia(f "RIGHT_C15_COMMON_GND" "GND" list(48.25 28.7252) "L28_VIA030_C060")
    hiRoute(f "RIGHT_VDD48_NECK" "V3V3" "TOP" list(list(44.25 29.75) list(44.7 29.75) list(45.3 30.35)) list(0.25 0.25))
    hiRoute(f "RIGHT_VDD48_CAP" "V3V3" "TOP" list(list(45.3 30.35) list(47.3 30.3) list(49.5 30.3)) list(0.6 0.6))
    hiRoute(f "RIGHT_SWCLK_TOP" "SWCLK" "TOP" list(list(44.25 24.25) list(45.0 24.25) list(45.1 24.15) list(46.2 24.15)) list(0.16 0.16 0.16))
    hiRoute(f "RIGHT_GPIO_PA15_TOP" "GPIO_PA15" "TOP" list(list(44.25 24.75) list(45.0 24.75) list(45.1 24.65) list(46.35 24.65) list(46.8 24.65)) list(0.16 0.16 0.16 0.2))
    hiVia(f "RIGHT_SWO_VIA" "SWO" list(46.2 25.15) "HI_VIA026_C052_TENT")
    hiRoute(f "RIGHT_SWO_TOP" "SWO" "TOP" list(list(44.25 25.25) list(45.0 25.25) list(45.1 25.15) list(46.2 25.15)) list(0.16 0.16 0.16))
    hiRoute(f "RIGHT_SWO_BOTTOM_ANCHOR" "SWO" "BOTTOM" list(list(46.2 25.15) list(46.8 25.15)) list(0.2))
    hiRoute(f "RIGHT_GPIO_PB4_TOP" "GPIO_PB4" "TOP" list(list(44.25 25.75) list(45.0 25.75) list(45.1 25.65) list(46.35 25.65) list(46.8 25.65)) list(0.16 0.16 0.16 0.2))
    hiVia(f "RIGHT_GPIO_PB5_VIA" "GPIO_PB5" list(46.2 26.15) "HI_VIA026_C052_TENT")
    hiRoute(f "RIGHT_GPIO_PB5_TOP" "GPIO_PB5" "TOP" list(list(44.25 26.25) list(45.0 26.25) list(45.1 26.15) list(46.2 26.15)) list(0.16 0.16 0.16))
    hiRoute(f "RIGHT_GPIO_PB5_BOTTOM_ANCHOR" "GPIO_PB5" "BOTTOM" list(list(46.2 26.15) list(46.8 26.15)) list(0.2))
    hiRoute(f "RIGHT_I2C_SCL_TOP" "I2C_SCL" "TOP" list(list(44.25 26.75) list(45.0 26.75) list(45.1 26.65) list(46.35 26.65) list(46.8 26.65)) list(0.16 0.16 0.16 0.2))
    hiVia(f "RIGHT_I2C_SDA_VIA" "I2C_SDA" list(46.2 27.15) "HI_VIA026_C052_TENT")
    hiRoute(f "RIGHT_I2C_SDA_TOP" "I2C_SDA" "TOP" list(list(44.25 27.25) list(45.0 27.25) list(45.1 27.15) list(46.2 27.15)) list(0.16 0.16 0.16))
    hiRoute(f "RIGHT_I2C_SDA_BOTTOM_ANCHOR" "I2C_SDA" "BOTTOM" list(list(46.2 27.15) list(46.8 27.15)) list(0.2))
    hiRoute(f "RIGHT_BOOT0_TOP" "BOOT0" "TOP" list(list(44.25 27.75) list(45.0 27.75) list(45.1 27.65) list(46.35 27.65) list(46.8 27.65)) list(0.16 0.16 0.16 0.2))
    hiVia(f "RIGHT_GPIO_PB8_VIA" "GPIO_PB8" list(46.2 28.15) "HI_VIA026_C052_TENT")
    hiRoute(f "RIGHT_GPIO_PB8_TOP" "GPIO_PB8" "TOP" list(list(44.25 28.25) list(45.0 28.25) list(45.1 28.15) list(46.2 28.15)) list(0.16 0.16 0.16))
    hiRoute(f "RIGHT_GPIO_PB8_BOTTOM_ANCHOR" "GPIO_PB8" "BOTTOM" list(list(46.2 28.15) list(46.8 28.15)) list(0.2))
    hiRoute(f "RIGHT_GPIO_PB9_TOP" "GPIO_PB9" "TOP" list(list(44.25 28.75) list(45.0 28.75) list(45.1 28.65) list(45.7 28.65)) list(0.16 0.16 0.16))
    hiVia(f "RIGHT_R28_GND_RETURN" "GND" list(51.3 29.2) "L28_VIA030_C060")
    hiRoute(f "RIGHT_R28_GND_TOP" "GND" "TOP" list(list(51.3236 28.0) list(51.3 28.0236) list(51.3 29.2)) list(0.6 0.6))
    hiVia(f "RIGHT_GPIO_PB9_VIA" "GPIO_PB9" list(45.7 28.65) "HI_VIA026_C052_TENT")
    hiRoute(f "RIGHT_GPIO_PB9_BOTTOM_ANCHOR" "GPIO_PB9" "BOTTOM" list(list(45.7 28.65) list(46.35 28.65) list(46.8 28.65)) list(0.16 0.2))
    hiRoute(f "RIGHT_SCL_EXPLICIT" "I2C_SCL" "TOP" list(list(46.8 26.65) list(47.0 26.45) list(54.0 26.45) list(55.5 27.95) list(55.5 34.18) list(57.7 34.18) list(58.5 34.98) list(58.5 35.0)) list(0.2 0.2 0.2 0.2 0.2 0.2 0.2))
    hiRoute(f "RIGHT_SDA_EXPLICIT_BOTTOM" "I2C_SDA" "BOTTOM" list(list(46.8 27.15) list(60.0 27.15) list(60.0 36.0) list(59.2 36.8)) list(0.2 0.2 0.2))
    hiVia(f "RIGHT_SDA_FAR_VIA" "I2C_SDA" list(59.2 36.8) "L28_VIA030_C060")
    hiRoute(f "RIGHT_SDA_FAR_TOP" "I2C_SDA" "TOP" list(list(59.2 36.8) list(59.0 37.0) list(58.5 37.0)) list(0.2 0.2))
    hiRoute(f "RIGHT_BOOT_DIRECT_TOP" "BOOT0" "TOP" list(list(46.8 27.65) list(47.27 27.18) list(52.8984 27.18) list(52.8984 28.0)) list(0.2 0.2 0.2))
    hiRoute(f "RIGHT_BOOT_R28_J8" "BOOT0" "TOP" list(list(52.8984 28.0) list(53.3 28.0) list(54.0 28.7) list(54.0 30.73)) list(0.2 0.2 0.2))
    hiRoute(f "RIGHT_PA15_DIRECT_EAST" "GPIO_PA15" "TOP" list(list(46.8 24.65) list(47.2 24.25) list(61.0 24.25)) list(0.2 0.2))
    hiVia(f "RIGHT_PA15_FAR_VIA" "GPIO_PA15" list(61.0 24.25) "L28_VIA030_C060")
    hiRoute(f "RIGHT_PB4_DIRECT_EAST" "GPIO_PB4" "TOP" list(list(46.8 25.65) list(47.0 25.85) list(61.8 25.85)) list(0.2 0.2))
    hiVia(f "RIGHT_PB4_FAR_VIA" "GPIO_PB4" list(61.8 25.85) "L28_VIA030_C060")
    hiRoute(f "RIGHT_PB5_BOTTOM_EAST" "GPIO_PB5" "BOTTOM" list(list(46.8 26.15) list(47.2 26.55) list(56.5 26.55)) list(0.2 0.2))
    hiVia(f "RIGHT_PB5_MID_VIA" "GPIO_PB5" list(56.5 26.55) "L28_VIA030_C060")
    hiRoute(f "RIGHT_PB5_TOP_EAST" "GPIO_PB5" "TOP" list(list(56.5 26.55) list(62.6 26.55)) list(0.2))
    hiVia(f "RIGHT_PB5_FAR_VIA" "GPIO_PB5" list(62.6 26.55) "L28_VIA030_C060")
    hiRoute(f "RIGHT_PB8_BOTTOM_EAST" "GPIO_PB8" "BOTTOM" list(list(46.8 28.15) list(47.2 27.95) list(59.0 27.95)) list(0.2 0.2))
    hiVia(f "RIGHT_PB8_MID_VIA" "GPIO_PB8" list(59.0 27.95) "L28_VIA030_C060")
    hiRoute(f "RIGHT_PB8_TOP_EAST" "GPIO_PB8" "TOP" list(list(59.0 27.95) list(64.0 27.95)) list(0.2))
    hiVia(f "RIGHT_PB8_FAR_VIA" "GPIO_PB8" list(64.0 27.95) "L28_VIA030_C060")
    hiRoute(f "RIGHT_PB9_BOTTOM_ESCAPE" "GPIO_PB9" "BOTTOM" list(list(46.8 28.65) list(47.3 28.65) list(47.5 28.85) list(47.5 29.5) list(49.8 31.8)) list(0.2 0.2 0.2 0.2))
    hiVia(f "RIGHT_PB9_FAR_VIA" "GPIO_PB9" list(49.8 31.8) "L28_VIA030_C060")
    hiRoute(f "RIGHT_SWO_BOTTOM_ESCAPE" "SWO" "BOTTOM" list(list(46.8 25.15) list(47.5 25.85) list(50.7 25.85) list(53.05 23.5) list(54.0 23.5)) list(0.2 0.2 0.2 0.2))
    hiVia(f "RIGHT_SWO_FAR_VIA" "SWO" list(54.0 23.5) "L28_VIA030_C060")
    hiRoute(f "RIGHT_LONG_GPIO_PA15_0_R0" "GPIO_PA15" "BOTTOM" list(list(61.0 24.25) list(61.0 54.73) list(60.73 55.0)) list(0.2 0.2))
    hiRoute(f "RIGHT_LONG_GPIO_PB4_0_R0" "GPIO_PB4" "BOTTOM" list(list(61.8 25.85) list(61.8 53.53) list(63.27 55.0)) list(0.2 0.2))
    hiRoute(f "RIGHT_LONG_GPIO_PB5_0_R0" "GPIO_PB5" "BOTTOM" list(list(62.6 26.55) list(62.6 51.79) list(65.81 55.0)) list(0.2 0.2))
    hiRoute(f "RIGHT_LONG_GPIO_PB8_0_R0" "GPIO_PB8" "BOTTOM" list(list(64.0 27.95) list(64.0 50.65) list(68.35 55.0)) list(0.2 0.2))
    hiRoute(f "RIGHT_LONG_GPIO_PB9_0_R0" "GPIO_PB9" "TOP" list(list(49.8 31.8) list(51.25 33.25) list(51.25 42.45) list(62.7 53.9) list(69.79 53.9) list(70.89 55.0)) list(0.2 0.2 0.2 0.2 0.2))
    hiRoute(f "RIGHT_LONG_SWO_0_R0" "SWO" "TOP" list(list(54.0 23.5) list(55.95 21.55) list(62.15 21.55) list(63.7 20.0)) list(0.2 0.2 0.2))
    hiVia(f "RIGHT_RETURN_RIGHT_SDA_FAR_VIA" "GND" list(59.2 37.9) "L28_VIA030_C060")
    hiVia(f "RIGHT_RETURN_RIGHT_PA15_FAR_VIA" "GND" list(61.0 23.35) "L28_VIA030_C060")
    hiVia(f "RIGHT_RETURN_RIGHT_PB4_FAR_VIA" "GND" list(61.8 24.95) "L28_VIA030_C060")
    hiVia(f "RIGHT_RETURN_RIGHT_PB5_MID_VIA" "GND" list(56.757 25.092) "L28_VIA030_C060")
    hiVia(f "RIGHT_RETURN_RIGHT_PB5_FAR_VIA" "GND" list(62.6 25.65) "L28_VIA030_C060")
    hiVia(f "RIGHT_RETURN_RIGHT_PB8_MID_VIA" "GND" list(58.55 28.729) "L28_VIA030_C060")
    hiVia(f "RIGHT_RETURN_RIGHT_PB8_FAR_VIA" "GND" list(63.55 27.171) "L28_VIA030_C060")
    hiVia(f "RIGHT_RETURN_RIGHT_SWO_FAR_VIA" "GND" list(53.844 22.614) "L28_VIA030_C060")
    hiRoute(f "HI_2L_I2C_SCL_1_R1" "I2C_SCL" "TOP" list(list(58.5 35.0) list(63.75 40.25) list(74.0 40.25) list(74.0 40.27)) list(0.2 0.2 0.2))
    hiRoute(f "HI_2L_I2C_SDA_1_R1" "I2C_SDA" "TOP" list(list(58.5 37.0) list(59.8 37.0) list(64.15 41.35) list(74.95 41.35) list(75.1 41.2) list(75.1 38.85) list(74.0 37.75) list(74.0 37.73)) list(0.2 0.2 0.2 0.2 0.2 0.2 0.2))
    hiRoute(f "RIGHT_SWCLK_TOP_WEST_BRIDGE" "SWCLK" "TOP" list(list(46.2 24.15) list(47.95 22.4)) list(0.2))
    hiVia(f "RIGHT_SWCLK_WEST_BRIDGE_V" "SWCLK" list(47.95 22.4) "L28_VIA030_C060")
    hiRoute(f "RIGHT_SWCLK_BOTTOM_BRIDGE" "SWCLK" "BOTTOM" list(list(47.95 22.4) list(48.65 23.1) list(51.0 23.1) list(51.8 22.3) list(51.8 21.2) list(57.0 21.2) list(57.4 20.8)) list(0.2 0.2 0.2 0.2 0.2 0.2))
    hiVia(f "RIGHT_SWCLK_EAST_BRIDGE_V" "SWCLK" list(57.4 20.8) "L28_VIA030_C060")
    hiRoute(f "RIGHT_SWCLK_TOP_EAST_BRIDGE" "SWCLK" "TOP" list(list(57.4 20.8) list(57.82 20.8) list(58.62 20.0)) list(0.2 0.2))
    hiVia(f "RIGHT_SWCLK_WEST_RETURN" "GND" list(46.8 22.5) "L28_VIA030_C060")
    hiVia(f "RIGHT_SWCLK_EAST_RETURN" "GND" list(57.35 19.31) "L28_VIA030_C060")
    hiVia(f "RIGHT_SWCLK_MID_RETURN" "GND" list(52.8 22.8) "L28_VIA030_C060")
    hiVia(f "HI_4L_BOOT_SERVICE_1_V1" "BOOT_SERVICE" list(57.4 33.4) "L28_VIA030_C060")
    hiRoute(f "HI_4L_BOOT_SERVICE_1_R1" "BOOT_SERVICE" "TOP" list(list(56.7 32.6764) list(56.7 32.7) list(57.4 33.4)) list(0.2 0.2))
    hiRoute(f "HI_4L_BOOT_SERVICE_1_R2" "BOOT_SERVICE" "BOTTOM" list(list(57.4 33.4) list(54.15 33.4) list(54.0 33.25) list(54.0 33.27)) list(0.2 0.2 0.2))
    hiVia(f "HI_4L_BOOT1_1_V2" "BOOT1" list(32.35 23.85) "L28_VIA030_C060")
    hiRoute(f "HI_4L_BOOT1_1_R3" "BOOT1" "TOP" list(list(32.35 23.85) list(32.25 23.85) list(31.4 23.0)) list(0.2 0.2))
    hiVia(f "HI_4L_CAN_TXD_1_V1" "CAN_TXD" list(47.7 18.3) "L28_VIA030_C060")
    hiVia(f "HI_4L_CAN_TXD_1_V2" "CAN_TXD" list(50.25 18.3) "L28_VIA030_C060")
    hiRoute(f "HI_4L_CAN_TXD_1_R1" "CAN_TXD" "TOP" list(list(44.4764 18.3) list(47.7 18.3)) list(0.2))
    hiRoute(f "HI_4L_CAN_TXD_1_R2" "CAN_TXD" "BOTTOM" list(list(47.7 18.3) list(50.25 18.3)) list(0.2))
    hiRoute(f "HI_4L_CAN_TXD_1_R3" "CAN_TXD" "TOP" list(list(50.25 18.3) list(57.5 18.3) list(57.95 18.75) list(61.15 18.75) list(62.0 17.9) list(61.9764 17.9)) list(0.2 0.2 0.2 0.2 0.2))
    hiRoute(f "LEFT_BOOT1_BOTTOM_RESHAPE" "BOOT1" "BOTTOM" list(list(34.4 26.0) list(35.6 24.8) list(35.6 23.85) list(32.35 23.85)) list(0.2 0.2 0.2))
    hiRoute(f "ROOT_SWDIO_BOTTOM" "SWDIO" "BOTTOM" list(list(41.52 21.25) list(41.52 21.72) list(42.0 22.2) list(44.15 22.2) list(44.4 21.95)) list(0.2 0.2 0.2 0.2))
    hiVia(f "ROOT_SWDIO_EAST_V" "SWDIO" list(44.4 21.95) "L28_VIA030_C060")
    hiRoute(f "ROOT_SWDIO_TOP" "SWDIO" "TOP" list(list(44.4 21.95) list(44.6 21.75) list(54.33 21.75) list(56.08 20.0)) list(0.2 0.2 0.2))
    hiRoute(f "ROOT_UART_RX_BOTTOM" "PA10_UART_RX" "BOTTOM" list(list(40.0 20.5) list(40.0 20.3) list(48.4 20.3) list(50.1 22.0) list(50.1 22.4)) list(0.2 0.2 0.2 0.2))
    hiVia(f "ROOT_UART_RX_EAST_V" "PA10_UART_RX" list(50.1 22.4) "L28_VIA030_C060")
    hiRoute(f "ROOT_UART_RX_TOP" "PA10_UART_RX" "TOP" list(list(50.1 22.4) list(50.1 23.4984) list(50.1016 23.5)) list(0.2 0.2))
    hiRoute(f "ROOT_UART_TX_BOTTOM" "PA9_UART_TX" "BOTTOM" list(list(39.7 21.7) list(40.4 21.7) list(40.8 21.3) list(40.8 20.85) list(40.95 20.7) list(41.85 20.7) list(41.95 20.8) list(46.0 20.8) list(46.3 21.1)) list(0.2 0.2 0.2 0.2 0.16 0.2 0.2 0.2))
    hiVia(f "ROOT_UART_TX_EAST_V" "PA9_UART_TX" list(46.3 21.1) "L28_VIA030_C060")
    hiRoute(f "ROOT_UART_TX_TOP" "PA9_UART_TX" "TOP" list(list(46.3 21.1) list(45.6016 20.4016) list(45.6016 19.9)) list(0.2 0.2))
    hiRoute(f "ROOT_ATTACH_BOTTOM" "USB_ATTACH_N" "BOTTOM" list(list(39.0 21.2) list(39.1 21.1) list(39.1 20.4) list(39.7 19.8) list(39.7 18.6) list(43.6 18.6) list(45.9 16.3) list(50.8 16.3)) list(0.2 0.2 0.2 0.2 0.2 0.2 0.2))
    hiVia(f "ROOT_SWDIO_RETURN_COMMON" "GND" list(45.3 22.55) "L28_VIA030_C060")
    hiPhysicalTerminalContract(f list(list("J2" "SH4" "GND" "L10_USB4105_SLOT060X140") list("J2" "SH3" "GND" "L10_USB4105_SLOT060X140") list("J2" "SH2" "GND" "L10_USB4105_SLOT060X170") list("J2" "SH1" "GND" "L10_USB4105_SLOT060X170") list("J2" "B1_A12" "GND" "L10_USB4105_SMD060X115") list("J2" "B4_A9" "USB_VBUS" "L10_USB4105_SMD060X115") list("J2" "B5" "USB_CC2" "L10_USB4105_SMD030X115") list("J2" "A8" nil "L10_USB4105_SMD030X115") list("J2" "B6" "USB_DP" "L10_USB4105_SMD030X115") list("J2" "A7" "USB_DM" "L10_USB4105_SMD030X115") list("J2" "A6" "USB_DP" "L10_USB4105_SMD030X115") list("J2" "B7" "USB_DM" "L10_USB4105_SMD030X115") list("J2" "A5" "USB_CC1" "L10_USB4105_SMD030X115") list("J2" "B8" nil "L10_USB4105_SMD030X115") list("J2" "A4_B9" "USB_VBUS" "L10_USB4105_SMD060X115") list("J2" "A1_B12" "GND" "L10_USB4105_SMD060X115") list("J3" "3" "GND" "VIA_1D0_1D54") list("J3" "2" "CAN_L" "VIA_1D0_1D54") list("J3" "1" "CAN_H" "VIA_1D0_1D54S") list("J4" "4" "GND" "VIA_1D0_1D54") list("J4" "3" "UART_RX" "VIA_1D0_1D54") list("J4" "2" "UART_TX" "VIA_1D0_1D54") list("J4" "1" "V3V3" "VIA_1D0_1D54S") list("J5" "4" "GND" "VIA_1D0_1D54") list("J5" "3" "I2C_SDA" "VIA_1D0_1D54") list("J5" "2" "I2C_SCL" "VIA_1D0_1D54") list("J5" "1" "V3V3" "VIA_1D0_1D54S") list("J6" "6" "GND" "VIAS_30_CIRCLE") list("J6" "5" "SPI_NSS" "VIAS_30_CIRCLE") list("J6" "4" "SPI_MISO" "VIAS_30_CIRCLE") list("J6" "3" "SPI_MOSI" "VIAS_30_CIRCLE") list("J6" "2" "SPI_SCK" "VIAS_30_CIRCLE") list("J6" "1" "V3V3" "VIAS_30_SQUARE") list("J9" "6" "SWO" "VIAS_30_CIRCLE") list("J9" "5" "NRST" "VIAS_30_CIRCLE") list("J9" "4" "SWCLK" "VIAS_30_CIRCLE") list("J9" "3" "SWDIO" "VIAS_30_CIRCLE") list("J9" "2" "GND" "VIAS_30_CIRCLE") list("J9" "1" "V3V3" "VIAS_30_SQUARE") list("J11" "8" "GPIO_PA3" "VIA_1D0_1D54") list("J11" "7" "GPIO_PA2" "VIA_1D0_1D54") list("J11" "6" "GPIO_PA1" "VIA_1D0_1D54") list("J11" "5" "GPIO_PC15" "VIA_1D0_1D54") list("J11" "4" "GPIO_PC14" "VIA_1D0_1D54") list("J11" "3" "GPIO_PC13" "VIA_1D0_1D54") list("J11" "2" "GND" "VIA_1D0_1D54") list("J11" "1" "V3V3" "VIA_1D0_1D54S") list("J12" "8" "GPIO_PB14" "VIA_1D0_1D54") list("J12" "7" "GPIO_PB13" "VIA_1D0_1D54") list("J12" "6" "GPIO_PB12" "VIA_1D0_1D54") list("J12" "5" "GPIO_PB11" "VIA_1D0_1D54") list("J12" "4" "GPIO_PB10" "VIA_1D0_1D54") list("J12" "3" "GPIO_PB1" "VIA_1D0_1D54") list("J12" "2" "GND" "VIA_1D0_1D54") list("J12" "1" "V3V3" "VIA_1D0_1D54S") list("J13" "8" "GPIO_PB9" "VIA_1D0_1D54") list("J13" "7" "GPIO_PB8" "VIA_1D0_1D54") list("J13" "6" "GPIO_PB5" "VIA_1D0_1D54") list("J13" "5" "GPIO_PB4" "VIA_1D0_1D54") list("J13" "4" "GPIO_PA15" "VIA_1D0_1D54") list("J13" "3" "GPIO_PB15" "VIA_1D0_1D54") list("J13" "2" "GND" "VIA_1D0_1D54") list("J13" "1" "V3V3" "VIA_1D0_1D54S") list("R23" "1" "PA4_SPI_NSS" "SMD_37X32RET") list("R23" "2" "SPI_NSS" "SMD_37X32RET") list("R21" "1" "PA5_SPI_SCK" "SMD_37X32RET") list("R21" "2" "SPI_SCK" "SMD_37X32RET") list("R24" "1" "PA6_SPI_MISO" "SMD_37X32RET") list("R24" "2" "SPI_MISO" "SMD_37X32RET") list("R22" "1" "PA7_SPI_MOSI" "SMD_37X32RET") list("R22" "2" "SPI_MOSI" "SMD_37X32RET") list("R25" "1" "V3V3" "SMD_37X32RET") list("R25" "2" "PA4_SPI_NSS" "SMD_37X32RET") list("R19" "1" "V3V3" "SMD_37X32RET") list("R19" "2" "I2C_SCL" "SMD_37X32RET") list("R20" "1" "V3V3" "SMD_37X32RET") list("R20" "2" "I2C_SDA" "SMD_37X32RET") list("C13" "1" "V3V3" "SMD_37X32RET") list("C13" "2" "GND" "SMD_37X32RET") list("C14" "1" "V3V3" "SMD_37X32RET") list("C14" "2" "GND" "SMD_37X32RET") list("C15" "1" "V3V3" "SMD_37X32RET") list("C15" "2" "GND" "SMD_37X32RET") list("C17" "1" "V3V3" "SMD_37X32RET") list("C17" "2" "GND" "SMD_37X32RET") list("C18" "1" "VDDA" "SMD_37X32RET") list("C18" "2" "GND" "SMD_37X32RET") list("C19" "1" "VDDA" "SMD_37X32RET") list("C19" "2" "GND" "SMD_37X32RET") list("C21" "1" "NRST" "SMD_37X32RET") list("C21" "2" "GND" "SMD_37X32RET") list("C22" "1" "OSC_IN" "SMD_37X32RET") list("C22" "2" "GND" "SMD_37X32RET") list("C23" "1" "XTAL_OUT" "SMD_37X32RET") list("C23" "2" "GND" "SMD_37X32RET") list("C24" "1" "ADC0" "SMD_37X32RET") list("C24" "2" "GND" "SMD_37X32RET") list("R26" "1" "V3V3" "SMD_37X32RET") list("R26" "2" "VDDA" "SMD_37X32RET") list("R27" "1" "V3V3" "SMD_37X32RET") list("R27" "2" "NRST" "SMD_37X32RET") list("R28" "1" "BOOT0" "SMD_37X32RET") list("R28" "2" "GND" "SMD_37X32RET") list("R29" "1" "BOOT1" "SMD_37X32RET") list("R29" "2" "GND" "SMD_37X32RET") list("R30" "1" "V3V3" "SMD_37X32RET") list("R30" "2" "BOOT_SERVICE" "SMD_37X32RET") list("R31" "1" "OSC_OUT" "SMD_37X32RET") list("R31" "2" "XTAL_OUT" "SMD_37X32RET") list("R32" "1" "ADC_IN" "SMD_37X32RET") list("R32" "2" "ADC0" "SMD_37X32RET") list("F1" "1" "VIN_RAW" "SMD_37X32RET") list("F1" "2" "VIN_FUSED" "SMD_37X32RET") list("C3" "1" "VIN_PROT" "SMD_37X32RET") list("C3" "2" "GND" "SMD_37X32RET") list("C4" "1" "BUCK_BOOT" "SMD_37X32RET") list("C4" "2" "BUCK_SW" "SMD_37X32RET") list("R1" "1" "V5" "SMD_37X32RET") list("R1" "2" "BUCK_FB" "SMD_37X32RET") list("R2" "1" "BUCK_FB" "SMD_37X32RET") list("R2" "2" "GND" "SMD_37X32RET") list("C7" "1" "V5" "SMD_37X32RET") list("C7" "2" "BUCK_FB" "SMD_37X32RET") list("C10" "1" "USB_VBUS" "SMD_37X32RET") list("C10" "2" "GND" "SMD_37X32RET") list("R3" "1" "USB_CC1" "SMD_37X32RET") list("R3" "2" "GND" "SMD_37X32RET") list("R4" "1" "USB_CC2" "SMD_37X32RET") list("R4" "2" "GND" "SMD_37X32RET") list("R5" "1" "PA12_SHARED" "SMD_37X32RET") list("R5" "2" "USB_DP" "SMD_37X32RET") list("R6" "1" "PA11_SHARED" "SMD_37X32RET") list("R6" "2" "USB_DM" "SMD_37X32RET") list("R7" "1" "USB_VBUS" "SMD_37X32RET") list("R7" "2" "VBUS_GATE" "SMD_37X32RET") list("R8" "1" "VBUS_GATE" "SMD_37X32RET") list("R8" "2" "GND" "SMD_37X32RET") list("R9" "1" "V3V3" "SMD_37X32RET") list("R9" "2" "VBUS_PRESENT_N" "SMD_37X32RET") list("R10" "1" "V3V3" "SMD_37X32RET") list("R10" "2" "USB_ATTACH_N" "SMD_37X32RET") list("R11" "1" "USB_PULLUP_SRC" "SMD_37X32RET") list("R11" "2" "USB_DP" "SMD_37X32RET") list("R12" "1" "PA12_SHARED" "SMD_37X32RET") list("R12" "2" "CAN_TXD" "SMD_37X32RET") list("R13" "1" "PA11_SHARED" "SMD_37X32RET") list("R13" "2" "CAN_RXD" "SMD_37X32RET") list("C11" "1" "V3V3" "SMD_37X32RET") list("C11" "2" "GND" "SMD_37X32RET") list("C12" "1" "V3V3" "SMD_37X32RET") list("C12" "2" "GND" "SMD_37X32RET") list("R14" "1" "V3V3" "SMD_37X32RET") list("R14" "2" "CAN_TXD" "SMD_37X32RET") list("R16" "1" "PA9_UART_TX" "SMD_37X32RET") list("R16" "2" "UART_TX" "SMD_37X32RET") list("R17" "1" "PA10_UART_RX" "SMD_37X32RET") list("R17" "2" "UART_RX" "SMD_37X32RET") list("R18" "1" "UART_RX" "SMD_37X32RET") list("R18" "2" "V3V3" "SMD_37X32RET") list("U1" "48" "V3V3" "L09_QFP120X030_M05") list("U1" "47" "GND" "L09_QFP120X030_M05") list("U1" "46" "GPIO_PB9" "L09_QFP120X030_M05") list("U1" "45" "GPIO_PB8" "L09_QFP120X030_M05") list("U1" "44" "BOOT0" "L09_QFP120X030_M05") list("U1" "43" "I2C_SDA" "L09_QFP120X030_M05") list("U1" "42" "I2C_SCL" "L09_QFP120X030_M05") list("U1" "41" "GPIO_PB5" "L09_QFP120X030_M05") list("U1" "40" "GPIO_PB4" "L09_QFP120X030_M05") list("U1" "39" "SWO" "L09_QFP120X030_M05") list("U1" "38" "GPIO_PA15" "L09_QFP120X030_M05") list("U1" "37" "SWCLK" "L09_QFP120X030_M05") list("U1" "36" "V3V3" "L09_QFP120X030_M05") list("U1" "35" "GND" "L09_QFP120X030_M05") list("U1" "34" "SWDIO" "L09_QFP120X030_M05") list("U1" "33" "PA12_SHARED" "L09_QFP120X030_M05") list("U1" "32" "PA11_SHARED" "L09_QFP120X030_M05") list("U1" "31" "PA10_UART_RX" "L09_QFP120X030_M05") list("U1" "30" "PA9_UART_TX" "L09_QFP120X030_M05") list("U1" "29" "USB_ATTACH_N" "L09_QFP120X030_M05") list("U1" "28" "GPIO_PB15" "L09_QFP120X030_M05") list("U1" "27" "GPIO_PB14" "L09_QFP120X030_M05") list("U1" "26" "GPIO_PB13" "L09_QFP120X030_M05") list("U1" "25" "GPIO_PB12" "L09_QFP120X030_M05") list("U1" "24" "V3V3" "L09_QFP120X030_M05") list("U1" "23" "GND" "L09_QFP120X030_M05") list("U1" "22" "GPIO_PB11" "L09_QFP120X030_M05") list("U1" "21" "GPIO_PB10" "L09_QFP120X030_M05") list("U1" "20" "BOOT1" "L09_QFP120X030_M05") list("U1" "19" "GPIO_PB1" "L09_QFP120X030_M05") list("U1" "18" "VBUS_PRESENT_N" "L09_QFP120X030_M05") list("U1" "17" "PA7_SPI_MOSI" "L09_QFP120X030_M05") list("U1" "16" "PA6_SPI_MISO" "L09_QFP120X030_M05") list("U1" "15" "PA5_SPI_SCK" "L09_QFP120X030_M05") list("U1" "14" "PA4_SPI_NSS" "L09_QFP120X030_M05") list("U1" "13" "GPIO_PA3" "L09_QFP120X030_M05") list("U1" "12" "GPIO_PA2" "L09_QFP120X030_M05") list("U1" "11" "GPIO_PA1" "L09_QFP120X030_M05") list("U1" "10" "ADC0" "L09_QFP120X030_M05") list("U1" "9" "VDDA" "L09_QFP120X030_M05") list("U1" "8" "GND" "L09_QFP120X030_M05") list("U1" "7" "NRST" "L09_QFP120X030_M05") list("U1" "6" "OSC_OUT" "L09_QFP120X030_M05") list("U1" "5" "OSC_IN" "L09_QFP120X030_M05") list("U1" "4" "GPIO_PC15" "L09_QFP120X030_M05") list("U1" "3" "GPIO_PC14" "L09_QFP120X030_M05") list("U1" "2" "GPIO_PC13" "L09_QFP120X030_M05") list("U1" "1" "V3V3" "L09_QFP120X030_M05") list("C16" "1" "V3V3" "SMD_40X50RET") list("C16" "2" "GND" "SMD_40X50RET") list("C20" "1" "VDDA" "SMD_40X50RET") list("C20" "2" "GND" "SMD_40X50RET") list("C8" "1" "V5" "SMD_40X50RET") list("C8" "2" "GND" "SMD_40X50RET") list("C9" "1" "V3V3" "SMD_40X50RET") list("C9" "2" "GND" "SMD_40X50RET") list("Y1" "4" "GND" "DE_SMD180X120") list("Y1" "3" "XTAL_OUT" "DE_SMD180X120") list("Y1" "2" "GND" "DE_SMD180X120") list("Y1" "1" "OSC_IN" "DE_SMD180X120") list("J7" "2" "GND" "VIA_1D0_1D54") list("J7" "1" "NRST" "VIA_1D0_1D54S") list("J8" "2" "BOOT0" "VIA_1D0_1D54") list("J8" "1" "BOOT_SERVICE" "VIA_1D0_1D54S") list("J10" "2" "GND" "VIA_1D0_1D54") list("J10" "1" "ADC_IN" "VIA_1D0_1D54S") list("J1" "2" "GND" "VIA_1D0_1D54") list("J1" "1" "VIN_RAW" "VIA_1D0_1D54S") list("D1" "2" "VIN_FUSED" "PAD67X78") list("D1" "1" "VIN_PROT" "PAD67X78") list("C1" "2" "GND" "VIA_1D0_1D54") list("C1" "1" "VIN_PROT" "VIA_1D0_1D54S") list("C2" "1" "VIN_PROT" "SMD_60X63RET") list("C2" "2" "GND" "SMD_60X63RET") list("C5" "1" "V5" "SMD_60X63RET") list("C5" "2" "GND" "SMD_60X63RET") list("C6" "1" "V5" "SMD_60X63RET") list("C6" "2" "GND" "SMD_60X63RET") list("R15" "1" "CAN_H" "SMD_60X63RET") list("R15" "2" "CAN_L" "SMD_60X63RET") list("U2" "6" "BUCK_BOOT" "PAD_0D6_1D1O") list("U2" "5" nil "PAD_0D6_1D1O") list("U2" "4" "BUCK_FB" "PAD_0D6_1D1O") list("U2" "3" "VIN_PROT" "PAD_0D6_1D1O") list("U2" "2" "BUCK_SW" "PAD_0D6_1D1O") list("U2" "1" "GND" "PAD_0D6_1D1O") list("U4" "6" "USB_DP" "PAD_0D6_1D1O") list("U4" "5" "USB_VBUS" "PAD_0D6_1D1O") list("U4" "4" "USB_DM" "PAD_0D6_1D1O") list("U4" "3" "USB_DM" "PAD_0D6_1D1O") list("U4" "2" "GND" "PAD_0D6_1D1O") list("U4" "1" "USB_DP" "PAD_0D6_1D1O") list("L1" "2" "V5" "DE_SMD143X550") list("L1" "1" "BUCK_SW" "DE_SMD143X550") list("U3" "1" "V5" "PAD_1D3_0D6") list("U3" "2" "GND" "PAD_1D3_0D6") list("U3" "3" "V5" "PAD_1D3_0D6") list("U3" "4" nil "PAD_1D3_0D6") list("U3" "5" "V3V3" "PAD_1D3_0D6") list("Q1" "1" "VBUS_GATE" "PAD_36_47") list("Q1" "2" "GND" "PAD_36_47") list("Q1" "3" "VBUS_PRESENT_N" "PAD_36_47") list("Q2" "1" "USB_ATTACH_N" "PAD_36_47") list("Q2" "2" "V3V3" "PAD_36_47") list("Q2" "3" "USB_PULLUP_SRC" "PAD_36_47") list("U5" "1" "CAN_TXD" "RE60X24") list("U5" "2" "GND" "RE60X24") list("U5" "3" "V3V3" "RE60X24") list("U5" "4" "CAN_RXD" "RE60X24") list("U5" "5" nil "RE60X24") list("U5" "6" "CAN_L" "RE60X24") list("U5" "7" "CAN_H" "RE60X24") list("U5" "8" nil "RE60X24")))
    hiHSEIsolationChallengeGraph("D:/001DIY/005lib/01AIEDA/learning/examples/lessonHI_38_50_20261021/logs/source_service_4L_b015_guarded_try09_interactive" list(46.35 29.4) "L2" list(list(42.2 39.8) list(44.2 39.8) list(47.8 33.5)))
    hiFiniteViaLineChallenge("D:/001DIY/005lib/01AIEDA/learning/examples/lessonHI_38_50_20261021/logs/source_service_4L_b015_guarded_try09_interactive" "HI_USB_MCU_S_1_4L" "TOP" "SWDIO" 0.2 0.3)
    t)
   progn(
    axlDBControl('drcEnable t)
    fprintf(f "HI_UNWIND_DRC_RESTORED=%L\n" axlDBControl('drcEnable))))
  unless(axlDBControl('drcEnable) error("Final DRC must be enabled\n"))
  hiFinalize(f "D:/001DIY/005lib/01AIEDA/learning/examples/lessonHI_38_50_20261021/logs/source_service_4L_b015_guarded_try09_interactive" "D:/001DIY/005lib/01AIEDA/learning/examples/lessonHI_38_50_20261021/native_candidates/HI_4L_source_b015_interactive.brd" "D:/001DIY/005lib/01AIEDA/learning/examples/lessonHI_38_50_20261021/library" list(list("U1.25" "SOUTH_SOURCE_25_VIA" t) list("U1.26" "SOUTH_SOURCE_26_VIA" t) list("U1.27" "SOUTH_SOURCE_27_VIA" t) list("U1.28" "SOUTH_SOURCE_28_VIA" t) list("U1.29" "SOUTH_SOURCE_29_VIA" t) list("U1.30" "SOUTH_SOURCE_30_VIA" t) list("U1.31" "SOUTH_SOURCE_31_VIA" t) list("U1.34" "SOUTH_SOURCE_34_VIA" t) list("U1.14" "R25.2" t) list("U1.35" "C14.2" t) list("U1.35" "U1.23" t) list("U1.25" "NODE_JS_1" t) list("U1.26" "NODE_JS_2" t) list("U1.27" "NODE_JS_3" t) list("U1.28" "NODE_JS_4" t) list("U1.24" "C13.1" t) list("U1.23" "C13.2" t) list("C13.2" "U1.35" t) list("U1.20" "R29.1" t) list("U1.18" "LEFT07_VBUS18_VIA" t) list("U1.19" "LEFT_SOURCE_19_VIA" t) list("U1.14" "R23.1" t) list("R23.2" "J6.5" t) list("U1.15" "R21.1" t) list("R21.2" "J6.2" t) list("U1.10" "C24.1" t) list("C24.1" "R32.2" t) list("R32.1" "J10.1" t) list("R25.1" "U1.24" t) list("U1.37" "J9.4" t) list("U1.38" "J13.4" t) list("U1.39" "J9.6" t) list("U1.40" "J13.5" t) list("U1.41" "J13.6" t) list("U1.42" "J5.2" t) list("U1.43" "J5.3" t) list("U1.44" "J8.2" t) list("U1.45" "J13.7" t) list("U1.46" "J13.8" t) list("U1.42" "R19.2" t) list("U1.43" "R20.2" t) list("R28.2" "U1.23" t) list("U1.48" "C15.1" t) list("U1.47" "C15.2" t) list("C15.1" "C16.1" t) list("C15.2" "C16.2" t) list("U1.37" "NODE_JS_5" t) list("U1.38" "NODE_JS_6" t) list("U1.39" "NODE_JS_7" t) list("U1.40" "NODE_JS_8" t) list("U1.41" "NODE_JS_9" t) list("U1.42" "NODE_JS_10" t) list("U1.43" "NODE_JS_11" t) list("U1.44" "NODE_JS_12" t) list("U1.45" "NODE_JS_13" t) list("U1.46" "NODE_JS_14" t) list("RIGHT_RETURN_RIGHT_SDA_FAR_VIA" "U1.23" t) list("RIGHT_RETURN_RIGHT_PA15_FAR_VIA" "U1.23" t) list("RIGHT_RETURN_RIGHT_PB4_FAR_VIA" "U1.23" t) list("RIGHT_RETURN_RIGHT_PB5_MID_VIA" "U1.23" t) list("RIGHT_RETURN_RIGHT_PB5_FAR_VIA" "U1.23" t) list("RIGHT_RETURN_RIGHT_PB8_MID_VIA" "U1.23" t) list("RIGHT_RETURN_RIGHT_PB8_FAR_VIA" "U1.23" t) list("RIGHT_RETURN_RIGHT_SWO_FAR_VIA" "U1.23" t) list("RIGHT_SWCLK_WEST_RETURN" "U1.23" t) list("RIGHT_SWCLK_EAST_RETURN" "U1.23" t) list("RIGHT_SWCLK_MID_RETURN" "U1.23" t) list("R19.2" "J5.2" t) list("R20.2" "J5.3" t) list("R30.2" "J8.1" t) list("R12.2" "R14.2" t) list("U1.34" "J9.3" t) list("U1.31" "R17.1" t) list("U1.30" "R16.1" t) list("U1.29" "R10.2" t) list("U1.35" "ROOT_SWDIO_RETURN_COMMON" t) list("GPIO_NORTH_COMMON_RETURN" "U1.23" t) list("SOUTH_RETURN_WEST" "U1.23" t) list("SOUTH_RETURN_MID" "U1.23" t) list("SOUTH_RETURN_EAST" "U1.23" t) list("RIGHT_PC14_RETURN" "U1.23" t) list("HSE_SINGLE_ANCHOR_REWORK" "U1.23" t) list("RIGHT_C15_COMMON_GND" "U1.23" t) list("RIGHT_R28_GND_RETURN" "U1.23" t) list("ROOT_SWDIO_RETURN_COMMON" "U1.23" t) list("C10.1" "J2.A4_B9" t) list("C10.1" "J2.B4_A9" t) list("C10.1" "R7.1" t) list("C10.1" "U4.5" t) list("J6.2" "R21.2" t) list("R13.1" "R6.1" t) list("R13.1" "U1.32" t) list("C4.2" "L1.1" t) list("C4.2" "U2.2" t) list("J2.A6" "J2.B6" t) list("J2.A6" "R11.2" t) list("J2.A6" "R5.2" t) list("J2.A6" "U4.1" t) list("J2.A6" "U4.6" t) list("Q2.1" "R10.2" t) list("R14.2" "U5.1" t) list("J3.2" "R15.2" t) list("J3.2" "U5.6" t) list("J2.B5" "R4.1" t) list("J3.1" "R15.1" t) list("J3.1" "U5.7" t) list("R23.1" "R25.2" t) list("R23.1" "U1.14" t) list("R31.1" "U1.6" t) list("J2.A5" "R3.1" t) list("R12.1" "R5.1" t) list("R12.1" "U1.33" t) list("D1.2" "F1.2" t) list("C1.2" "C10.2" t) list("C1.2" "C11.2" t) list("C1.2" "C12.2" t) list("C1.2" "C13.2" t) list("C1.2" "C14.2" t) list("C1.2" "C15.2" t) list("C1.2" "C16.2" t) list("C1.2" "C17.2" t) list("C1.2" "C18.2" t) list("C1.2" "C19.2" t) list("C1.2" "C2.2" t) list("C1.2" "C20.2" t) list("C1.2" "C21.2" t) list("C1.2" "C22.2" t) list("C1.2" "C23.2" t) list("C1.2" "C24.2" t) list("C1.2" "C3.2" t) list("C1.2" "C5.2" t) list("C1.2" "C6.2" t) list("C1.2" "C8.2" t) list("C1.2" "C9.2" t) list("C1.2" "J1.2" t) list("C1.2" "J10.2" t) list("C1.2" "J11.2" t) list("C1.2" "J12.2" t) list("C1.2" "J13.2" t) list("C1.2" "J2.SH1" t) list("C1.2" "J2.SH2" t) list("C1.2" "J2.SH3" t) list("C1.2" "J2.SH4" t) list("C1.2" "J3.3" t) list("C1.2" "J4.4" t) list("C1.2" "J5.4" t) list("C1.2" "J6.6" t) list("C1.2" "J7.2" t) list("C1.2" "J9.2" t) list("C1.2" "R2.2" t) list("C1.2" "R3.2" t) list("C1.2" "R4.2" t) list("C1.2" "U1.23" t) list("C1.2" "U1.35" t) list("C1.2" "U1.47" t) list("C1.2" "U1.8" t) list("C1.2" "U2.1" t) list("C1.2" "U3.2" t) list("C1.2" "U4.2" t) list("C1.2" "U5.2" t) list("C1.2" "Y1.2" t) list("C1.2" "Y1.4" t) list("C24.1" "U1.10" t) list("J4.3" "R18.1" t) list("C4.1" "U2.6" t) list("C11.1" "C12.1" t) list("C11.1" "C13.1" t) list("C11.1" "C14.1" t) list("C11.1" "C15.1" t) list("C11.1" "C16.1" t) list("C11.1" "C17.1" t) list("C11.1" "C9.1" t) list("C11.1" "J11.1" t) list("C11.1" "J12.1" t) list("C11.1" "J13.1" t) list("C11.1" "J4.1" t) list("C11.1" "J5.1" t) list("C11.1" "J6.1" t) list("C11.1" "J9.1" t) list("C11.1" "Q2.2" t) list("C11.1" "R10.1" t) list("C11.1" "R14.1" t) list("C11.1" "R18.2" t) list("C11.1" "R19.1" t) list("C11.1" "R20.1" t) list("C11.1" "R25.1" t) list("C11.1" "R26.1" t) list("C11.1" "R27.1" t) list("C11.1" "R30.1" t) list("C11.1" "R9.1" t) list("C11.1" "U1.1" t) list("C11.1" "U1.24" t) list("C11.1" "U1.36" t) list("C11.1" "U1.48" t) list("C11.1" "U3.5" t) list("C11.1" "U5.3" t) list("Q2.3" "R11.1" t) list("R24.1" "U1.16" t) list("C18.1" "C19.1" t) list("C18.1" "C20.1" t) list("C18.1" "R26.2" t) list("C18.1" "U1.9" t) list("Q1.3" "R9.2" t) list("F1.1" "J1.1" t) list("J6.5" "R23.2" t) list("C5.1" "C6.1" t) list("C5.1" "C7.1" t) list("C5.1" "C8.1" t) list("C5.1" "L1.2" t) list("C5.1" "R1.1" t) list("C5.1" "U3.1" t) list("C5.1" "U3.3" t) list("J6.3" "R22.2" t) list("J6.4" "R24.2" t) list("C7.2" "R1.2" t) list("C7.2" "R2.1" t) list("C7.2" "U2.4" t) list("J10.1" "R32.1" t) list("R21.1" "U1.15" t) list("R22.1" "U1.17" t) list("C23.1" "R31.2" t) list("C23.1" "Y1.3" t) list("J2.A7" "J2.B7" t) list("J2.A7" "R6.2" t) list("J2.A7" "U4.3" t) list("J2.A7" "U4.4" t) list("Q1.1" "R7.2" t) list("Q1.1" "R8.1" t) list("C22.1" "U1.5" t) list("C22.1" "Y1.1" t) list("C1.1" "C2.1" t) list("C1.1" "C3.1" t) list("C1.1" "D1.1" t) list("C1.1" "U2.3" t) list("C21.1" "U1.7" t)))
  t))
