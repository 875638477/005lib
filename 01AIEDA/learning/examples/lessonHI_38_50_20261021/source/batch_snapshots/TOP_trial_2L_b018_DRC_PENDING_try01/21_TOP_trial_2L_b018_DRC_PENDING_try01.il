procedure(hiBatchProgram()
 let((f)
  f=outfile("D:/001DIY/005lib/01AIEDA/learning/examples/lessonHI_38_50_20261021/logs/TOP_trial_2L_b018_DRC_PENDING_try01/hi_batch_execution.txt")
  fprintf(f "HI_BATCH_DRC_BEFORE=%L\n" axlDBControl('drcEnable))
  unwindProtect(
   progn(
    axlDBControl('drcEnable nil)
    fprintf(f "HI_ASSEMBLY_ONLINE_DRC_TEMPORARILY_DISABLED=%L\n" axlDBControl('drcEnable))
    hiDeferredReferences=nil
    hiReferenceParamsBefore=nil
    hiRegistry=nil
    hiNodeDefinitions=list(list("N50_2L_N49_GPIO_PC13_ACCESS" "GPIO_PC13" "BOTTOM" list(42.0 28.9) "point") list("N50_2L_N49_GPIO_PC15_ACCESS" "GPIO_PC15" "BOTTOM" list(40.3 28.9) "point") list("N50_2L_N49_GPIO_PA1_ACCESS" "GPIO_PA1" "BOTTOM" list(37.5 29.6) "point") list("N50_2L_N49_GPIO_PA2_ACCESS" "GPIO_PA2" "BOTTOM" list(36.6 30.4) "point") list("N50_2L_N49_GPIO_PA3_ACCESS" "GPIO_PA3" "BOTTOM" list(35.2 31.65) "point") list("N50_2L_N49_PC14_TOP_TEMP" "GPIO_PC14" "TOP" list(41.75 31.25) "point") list("N50_2L_N49_PC14_VIA" "GPIO_PC14" "TOP" list(41.5 29.65) "via") list("N50_2L_N49_PC14_ACCESS" "GPIO_PC14" "BOTTOM" list(41.5 29.65) "point") list("N50_2L_HI_2L_GPIO_PC13_1_V1" "GPIO_PC13" "TOP" list(29.45 39.55) "via") list("N50_2L_HI_2L_GPIO_PC13_1_R1" "GPIO_PC13" "BOTTOM" list(34.05 34.95) "point") list("N50_2L_HI_2L_GPIO_PC13_1_R2" "GPIO_PC13" "TOP" list(29.45 39.55) "point") list("N50_2L_HI_2L_GPIO_PC14_1_V1" "GPIO_PC14" "TOP" list(31.25 39.9) "via") list("N50_2L_HI_2L_GPIO_PC14_1_R1" "GPIO_PC14" "BOTTOM" list(35.05 36.1) "point") list("N50_2L_HI_2L_GPIO_PC14_1_R2" "GPIO_PC14" "TOP" list(31.25 39.9) "point") list("N50_2L_HI_2L_GPIO_PC15_1_R1" "GPIO_PC15" "BOTTOM" list(33.55 34.5) "point") list("N50_2L_HI_2L_GPIO_PA1_1_R1" "GPIO_PA1" "BOTTOM" list(33.25 34.05) "point") list("N50_2L_HI_2L_GPIO_PA2_1_V1" "GPIO_PA2" "TOP" list(17.55 52.55) "via") list("N50_2L_HI_2L_GPIO_PA2_1_V2" "GPIO_PA2" "TOP" list(19.9 50.95) "via") list("N50_2L_HI_2L_GPIO_PA2_1_R1" "GPIO_PA2" "BOTTOM" list(33.0 33.6) "point") list("N50_2L_HI_2L_GPIO_PA2_1_R2" "GPIO_PA2" "TOP" list(17.55 52.55) "point") list("N50_2L_HI_2L_GPIO_PA2_1_R3" "GPIO_PA2" "BOTTOM" list(19.9 50.95) "point") list("N50_2L_HI_2L_GPIO_PA3_1_R1" "GPIO_PA3" "BOTTOM" list(32.75 33.15) "point") list("N50_2L_RETURN_1" "GND" "TOP" list(41.4 28.15) "via") list("N50_2L_RETURN_2" "GND" "TOP" list(30.05 40.25) "via") list("N50_2L_RETURN_3" "GND" "TOP" list(16.95 53.25) "via") list("N50_2L_RETURN_4" "GND" "TOP" list(20.5 50.25) "via") list("SOUTH_RX_CLEARANCE_REPLACE" "PA10_UART_RX" "TOP" list(40.25 22.75) "point") list("LEFT08_PB10_REVISED_TAIL" "GPIO_PB10" "TOP" list(36.65 25.75) "point") list("LEFT08_PB10_REVISED_VIA" "GPIO_PB10" "TOP" list(38.0 26.3) "via") list("NORTH09_PC15_BETWEEN_GND_VIAS" "GPIO_PC15" "BOTTOM" list(40.3 28.9) "point") list("RIGHT_FIX_PB9_TOP" "GPIO_PB9" "TOP" list(45.1 28.65) "point") list("RIGHT_FIX_PB9_BOTTOM" "GPIO_PB9" "BOTTOM" list(45.65 28.65) "point") list("RIGHT_FIX_VSS47_NECK" "GND" "TOP" list(45.05 29.25) "point") list("RIGHT_FIX_VSS47_NORMAL" "GND" "TOP" list(45.4 29.54) "point") list("RIGHT_FIX_VDD48_NECK" "V3V3" "TOP" list(44.7 29.75) "point") list("RIGHT_FIX_VDD48_NORMAL" "V3V3" "TOP" list(45.3 30.46) "point") list("RIGHT_FIX_VBAT_NECK" "V3V3" "TOP" list(42.75 31.25) "point") list("RIGHT_FIX_VBAT_NORMAL" "V3V3" "TOP" list(43.55 31.4) "point") list("RIGHT_FIX_PB9_SMALL_NEW" "GPIO_PB9" "TOP" list(45.65 28.65) "via") list("HI_2L_NRST_1_V1" "NRST" "TOP" list(39.05 42.1) "via") list("HI_2L_NRST_1_R1" "NRST" "TOP" list(39.6764 41.3) "point") list("HI_2L_NRST_1_R2" "NRST" "BOTTOM" list(39.05 42.1) "point") list("HI_2L_NRST_2_R1" "NRST" "BOTTOM" list(34.27 43.0) "point") list("HI_2L_NRST_3_R1" "NRST" "BOTTOM" list(61.16 20.0) "point") list("HI_2L_VBUS_PRESENT_N_1_V1" "VBUS_PRESENT_N" "TOP" list(51.15 11.7) "via") list("HI_2L_VBUS_PRESENT_N_1_R2" "VBUS_PRESENT_N" "TOP" list(51.15 11.7) "point") list("HI_2L_UART_TX_1_V1" "UART_TX" "TOP" list(54.85 18.95) "via") list("HI_2L_UART_TX_1_R1" "UART_TX" "TOP" list(47.1764 19.9) "point") list("HI_2L_UART_TX_1_R2" "UART_TX" "BOTTOM" list(54.85 18.95) "point") list("UART_RX_SOURCE_REPOSE_TOP" "PA10_UART_RX" "TOP" list(50.1 22.4) "point") list("UART_RX_RECEIVER_TOP_W" "UART_RX" "TOP" list(50.12 25.0374) "point") list("UART_RX_BRIDGE1_W" "UART_RX" "TOP" list(55.7 25.05) "via") list("UART_RX_RECEIVER_BOTTOM_B1" "UART_RX" "BOTTOM" list(55.7 25.05) "point") list("UART_RX_BRIDGE1_E" "UART_RX" "TOP" list(57.8 25.05) "via") list("UART_RX_RECEIVER_TOP_E" "UART_RX" "TOP" list(57.8 25.05) "point") list("REM19_RETURN_NRST" "GND" "TOP" list(39.55 42.8) "via") list("REM19_RETURN_UART_TX" "GND" "TOP" list(54.75 19.75) "via") list("REM19_RETURN_VBUS_PRESENT_N" "GND" "TOP" list(50.95 12.5) "via") list("J2_LEFT_GND_PIN_NECK" "GND" "TOP" list(36.8 7.355) "point") list("J2_LEFT_GND_SHELL_WIDE" "GND" "TOP" list(35.9 7.355) "point") list("J2_RIGHT_GND_PIN_NECK" "GND" "TOP" list(43.2 7.355) "point") list("J2_RIGHT_GND_SHELL_WIDE" "GND" "TOP" list(44.1 7.355) "point") list("CAN2L_PHY_V" "CAN_RXD" "TOP" list(61.45 12.2) "via") list("CAN2L_PHY_TOP" "CAN_RXD" "TOP" list(64.0 12.19) "point") list("CAN2L_BOTTOM_PERIMETER" "CAN_RXD" "BOTTOM" list(61.45 12.2) "point") list("CAN2L_USB_WEST_V" "CAN_RXD" "TOP" list(34.45 1.95) "via") list("CAN2L_WEST_TOP_DNP" "CAN_RXD" "TOP" list(34.45 1.95) "point") list("CAN2L_PHY_RETURN" "GND" "TOP" list(61.7 11.2) "via") list("CAN2L_REFERENCE_CROSS_LEFT" "GND" "TOP" list(34.25 17.25) "via") list("CAN2L_REFERENCE_CROSS_RIGHT" "GND" "TOP" list(35.2 18.5) "via") list("CAN2L_REFERENCE_COPLANAR_BRIDGE" "GND" "TOP" list(34.25 17.25) "point") list("HI_2L_VBUS_PRESENT_N_1_R1" "VBUS_PRESENT_N" "BOTTOM" list(34.6 26.85) "point") list("VDD24_SHORTER_NORMAL_FLARE" "V3V3" "TOP" list(35.1 23.6) "point") list("SH2_TO_COMMON_SH4_TOP_BRIDGE" "GND" "TOP" list(44.32 6.78) "point") list("GPIO_NORTH_PC15_DIRECT_WEST" "GPIO_PC15" "BOTTOM" list(40.3 28.9) "point") list("GPIO_PA1_INWARD_FANOUT" "GPIO_PA1" "TOP" list(37.75 31.25) "point") list("GPIO_PA1_INWARD_VIA" "GPIO_PA1" "TOP" list(37.5 29.6) "via") list("GPIO_PA2_INWARD_FANOUT" "GPIO_PA2" "TOP" list(37.25 31.25) "point") list("GPIO_PA2_INWARD_VIA" "GPIO_PA2" "TOP" list(36.6 30.4) "via") list("GPIO_PA3_INWARD_FANOUT" "GPIO_PA3" "TOP" list(35.75 29.75) "point") list("GPIO_PA3_INWARD_VIA" "GPIO_PA3" "TOP" list(35.2 31.65) "via") list("GPIO_NORTH_COMMON_RETURN" "GND" "TOP" list(39.5 28.0) "via") list("SOUTH_SOURCE_25_NECK" "GPIO_PB12" "TOP" list(37.25 22.75) "point") list("SOUTH_SOURCE_25_VIA" "GPIO_PB12" "TOP" list(37.0 21.25) "via") list("SOUTH_SOURCE_26_NECK" "GPIO_PB13" "TOP" list(37.75 22.75) "point") list("SOUTH_SOURCE_26_VIA" "GPIO_PB13" "TOP" list(37.5 20.75) "via") list("SOUTH_SOURCE_27_NECK" "GPIO_PB14" "TOP" list(38.25 22.75) "point") list("SOUTH_SOURCE_27_VIA" "GPIO_PB14" "TOP" list(38.0 21.25) "via") list("SOUTH_SOURCE_28_NECK" "GPIO_PB15" "TOP" list(38.75 22.75) "point") list("SOUTH_SOURCE_28_VIA" "GPIO_PB15" "TOP" list(38.5 20.7) "via") list("SOUTH_SOURCE_29_NECK" "USB_ATTACH_N" "TOP" list(39.25 22.75) "point") list("SOUTH_SOURCE_29_VIA" "USB_ATTACH_N" "TOP" list(39.0 21.2) "via") list("SOUTH_SOURCE_30_NECK" "PA9_UART_TX" "TOP" list(39.75 22.75) "point") list("SOUTH_SOURCE_30_VIA" "PA9_UART_TX" "TOP" list(39.7 21.7) "via") list("SOUTH_SOURCE_31_NECK" "PA10_UART_RX" "TOP" list(40.25 22.75) "point") list("SOUTH_SOURCE_31_VIA" "PA10_UART_RX" "TOP" list(40.0 20.5) "via") list("SOUTH_RETURN_WEST" "GND" "TOP" list(35.8 21.95) "via") list("SOUTH_RETURN_MID" "GND" "TOP" list(38.0 20.0) "via") list("SOUTH_RETURN_EAST" "GND" "TOP" list(38.8 19.7) "via") list("SOUTH_SOURCE_34_NECK" "SWDIO" "TOP" list(41.75 22.75) "point") list("SOUTH_SOURCE_34_VIA" "SWDIO" "TOP" list(41.52 21.25) "via") list("SOUTH_C14_GND_NECK" "GND" "TOP" list(42.25 22.75) "point") list("SOUTH_C14_GND_WIDE" "GND" "TOP" list(42.28 21.37) "point") list("SOUTH_GPIO12_BOTTOM_NECK" "GPIO_PB12" "BOTTOM" list(37.0 21.25) "point") list("SOUTH_GPIO12_BOTTOM_EXIT" "GPIO_PB12" "BOTTOM" list(36.5 21.25) "point") list("SOUTH_GPIO13_BOTTOM_NECK" "GPIO_PB13" "BOTTOM" list(37.5 20.75) "point") list("SOUTH_GPIO14_BOTTOM_NECK" "GPIO_PB14" "BOTTOM" list(38.0 21.25) "point") list("SOUTH_GPIO14_BOTTOM_EXIT" "GPIO_PB14" "BOTTOM" list(38.0 21.9) "point") list("SOUTH_GPIO15_BOTTOM_NECK" "GPIO_PB15" "BOTTOM" list(38.5 20.7) "point") list("LEFT_C13_VDD24_NECK" "V3V3" "TOP" list(35.75 24.25) "point") list("LEFT_C13_VDD24_WIDE" "V3V3" "TOP" list(35.1 23.2) "point") list("LEFT_C13_VSS23_NECK" "GND" "TOP" list(35.75 24.75) "point") list("LEFT_C13_VSS23_WIDE" "GND" "TOP" list(34.7 24.75) "point") list("LEFT_C13_COMMON_RETURN" "GND" "TOP" list(34.0 24.1748) "point") list("LEFT_V3_PERIPHERAL_REROUTE" "V3V3" "TOP" list(33.3 22.5) "point") list("LEFT_SOURCE_19_NECK" "GPIO_PB1" "TOP" list(35.75 26.75) "point") list("LEFT_SOURCE_19_VIA" "GPIO_PB1" "TOP" list(38.3 27.35) "via") list("LEFT_SOURCE_21_NECK" "GPIO_PB10" "TOP" list(35.75 25.75) "point") list("LEFT_SOURCE_21_VIA" "GPIO_PB10" "TOP" list(38.0 26.3) "via") list("LEFT_SOURCE_22_NECK" "GPIO_PB11" "TOP" list(35.75 25.25) "point") list("LEFT_SOURCE_22_VIA" "GPIO_PB11" "TOP" list(33.7 25.3) "via") list("LEFT_BOOT1_SOURCE_NECK" "BOOT1" "TOP" list(35.75 26.25) "point") list("LEFT_BOOT1_SOURCE_VIA" "BOOT1" "TOP" list(34.4 26.0) "via") list("LEFT07_VBUS18_SOURCE" "VBUS_PRESENT_N" "TOP" list(35.75 27.25) "point") list("LEFT07_VBUS18_VIA" "VBUS_PRESENT_N" "TOP" list(34.6 26.85) "via") list("NSS01_MAIN_SOURCE" "PA4_SPI_NSS" "TOP" list(34.8 31.15) "point") list("NSS01_LOCAL_PULLUP_STUB" "PA4_SPI_NSS" "TOP" list(33.3984 32.1) "point") list("NSS01_SCK_SOURCE" "PA5_SPI_SCK" "TOP" list(34.385 30.215) "point") list("NSS01_ADC_SERIES_TO_LOCAL_CAP" "ADC0" "TOP" list(34.8 33.0) "point") list("NSS01_ADC_INPUT" "ADC_IN" "TOP" list(31.1016 35.5) "point") list("NSS01_R25_SUPPLY_VIA" "V3V3" "TOP" list(30.4 33.7) "via") list("NSS01_R25_SUPPLY_BOTTOM" "V3V3" "BOTTOM" list(30.7 32.0) "point") list("NSS01_R25_SUPPLY_TOP" "V3V3" "TOP" list(30.4 33.7) "point") list("NSS01_2L_ADD_2" "SPI_SCK" "TOP" list(32.0252 30.7) "point") list("NSS01_2L_ADD_5" "SPI_NSS" "TOP" list(31.8236 32.1) "point") list("RIGHT_PC14_SOUTH_BYPASS" "GPIO_PC14" "BOTTOM" list(43.6 25.2) "point") list("RIGHT_PC14_FINAL" "GPIO_PC14" "TOP" list(49.2 25.2) "via") list("RIGHT_PC14_RETURN" "GND" "TOP" list(48.2 25.0) "via") list("RIGHT_VSS47_NECK" "GND" "TOP" list(44.25 29.25) "point") list("RIGHT_VSS47_CAP_GROUND" "GND" "TOP" list(45.4 29.5) "point") list("HSE_SINGLE_ANCHOR_REWORK" "GND" "TOP" list(46.35 29.4) "via") list("RIGHT_C15_COMMON_GND" "GND" "TOP" list(48.25 28.7252) "via") list("RIGHT_VDD48_NECK" "V3V3" "TOP" list(44.25 29.75) "point") list("RIGHT_VDD48_CAP" "V3V3" "TOP" list(45.3 30.35) "point") list("RIGHT_SWCLK_TOP" "SWCLK" "TOP" list(44.25 24.25) "point") list("RIGHT_GPIO_PA15_TOP" "GPIO_PA15" "TOP" list(44.25 24.75) "point") list("RIGHT_SWO_VIA" "SWO" "TOP" list(46.2 25.15) "via") list("RIGHT_SWO_TOP" "SWO" "TOP" list(44.25 25.25) "point") list("RIGHT_SWO_BOTTOM_ANCHOR" "SWO" "BOTTOM" list(46.2 25.15) "point") list("RIGHT_GPIO_PB4_TOP" "GPIO_PB4" "TOP" list(44.25 25.75) "point") list("RIGHT_GPIO_PB5_VIA" "GPIO_PB5" "TOP" list(46.2 26.15) "via") list("RIGHT_GPIO_PB5_TOP" "GPIO_PB5" "TOP" list(44.25 26.25) "point") list("RIGHT_GPIO_PB5_BOTTOM_ANCHOR" "GPIO_PB5" "BOTTOM" list(46.2 26.15) "point") list("RIGHT_I2C_SCL_TOP" "I2C_SCL" "TOP" list(44.25 26.75) "point") list("RIGHT_I2C_SDA_VIA" "I2C_SDA" "TOP" list(46.2 27.15) "via") list("RIGHT_I2C_SDA_TOP" "I2C_SDA" "TOP" list(44.25 27.25) "point") list("RIGHT_I2C_SDA_BOTTOM_ANCHOR" "I2C_SDA" "BOTTOM" list(46.2 27.15) "point") list("RIGHT_BOOT0_TOP" "BOOT0" "TOP" list(44.25 27.75) "point") list("RIGHT_GPIO_PB8_VIA" "GPIO_PB8" "TOP" list(46.2 28.15) "via") list("RIGHT_GPIO_PB8_TOP" "GPIO_PB8" "TOP" list(44.25 28.25) "point") list("RIGHT_GPIO_PB8_BOTTOM_ANCHOR" "GPIO_PB8" "BOTTOM" list(46.2 28.15) "point") list("RIGHT_GPIO_PB9_TOP" "GPIO_PB9" "TOP" list(44.25 28.75) "point") list("RIGHT_R28_GND_RETURN" "GND" "TOP" list(51.3 29.2) "via") list("RIGHT_R28_GND_TOP" "GND" "TOP" list(51.3236 28.0) "point") list("RIGHT_GPIO_PB9_VIA" "GPIO_PB9" "TOP" list(45.65 28.65) "via") list("RIGHT_GPIO_PB9_BOTTOM_ANCHOR" "GPIO_PB9" "BOTTOM" list(45.65 28.65) "point") list("RIGHT_SCL_EXPLICIT" "I2C_SCL" "TOP" list(46.8 26.65) "point") list("RIGHT_SDA_EXPLICIT_BOTTOM" "I2C_SDA" "BOTTOM" list(46.8 27.15) "point") list("RIGHT_SDA_FAR_VIA" "I2C_SDA" "TOP" list(59.2 36.8) "via") list("RIGHT_SDA_FAR_TOP" "I2C_SDA" "TOP" list(59.2 36.8) "point") list("RIGHT_BOOT_DIRECT_TOP" "BOOT0" "TOP" list(46.8 27.65) "point") list("RIGHT_BOOT_R28_J8" "BOOT0" "TOP" list(52.8984 28.0) "point") list("RIGHT_PA15_DIRECT_EAST" "GPIO_PA15" "TOP" list(46.8 24.65) "point") list("RIGHT_PA15_FAR_VIA" "GPIO_PA15" "TOP" list(61.0 24.25) "via") list("RIGHT_PB4_DIRECT_EAST" "GPIO_PB4" "TOP" list(46.8 25.65) "point") list("RIGHT_PB4_FAR_VIA" "GPIO_PB4" "TOP" list(61.8 25.85) "via") list("RIGHT_PB5_BOTTOM_EAST" "GPIO_PB5" "BOTTOM" list(46.8 26.15) "point") list("RIGHT_PB5_MID_VIA" "GPIO_PB5" "TOP" list(56.5 26.55) "via") list("RIGHT_PB5_TOP_EAST" "GPIO_PB5" "TOP" list(56.5 26.55) "point") list("RIGHT_PB5_FAR_VIA" "GPIO_PB5" "TOP" list(62.6 26.55) "via") list("RIGHT_PB8_BOTTOM_EAST" "GPIO_PB8" "BOTTOM" list(46.8 28.15) "point") list("RIGHT_PB8_MID_VIA" "GPIO_PB8" "TOP" list(59.0 27.95) "via") list("RIGHT_PB8_TOP_EAST" "GPIO_PB8" "TOP" list(59.0 27.95) "point") list("RIGHT_PB8_FAR_VIA" "GPIO_PB8" "TOP" list(64.0 27.95) "via") list("RIGHT_PB9_BOTTOM_ESCAPE" "GPIO_PB9" "BOTTOM" list(46.8 28.65) "point") list("RIGHT_PB9_FAR_VIA" "GPIO_PB9" "TOP" list(49.8 31.8) "via") list("RIGHT_SWO_BOTTOM_ESCAPE" "SWO" "BOTTOM" list(46.8 25.15) "point") list("RIGHT_SWO_FAR_VIA" "SWO" "TOP" list(54.0 23.5) "via") list("RIGHT_LONG_GPIO_PA15_0_R0" "GPIO_PA15" "BOTTOM" list(61.0 24.25) "point") list("RIGHT_LONG_GPIO_PB4_0_R0" "GPIO_PB4" "BOTTOM" list(61.8 25.85) "point") list("RIGHT_LONG_GPIO_PB5_0_R0" "GPIO_PB5" "BOTTOM" list(62.6 26.55) "point") list("RIGHT_LONG_GPIO_PB8_0_R0" "GPIO_PB8" "BOTTOM" list(64.0 27.95) "point") list("RIGHT_LONG_GPIO_PB9_0_R0" "GPIO_PB9" "TOP" list(49.8 31.8) "point") list("RIGHT_LONG_SWO_0_R0" "SWO" "TOP" list(54.0 23.5) "point") list("RIGHT_RETURN_RIGHT_SDA_FAR_VIA" "GND" "TOP" list(59.374 37.785) "via") list("RIGHT_RETURN_RIGHT_PA15_FAR_VIA" "GND" "TOP" list(61.0 23.35) "via") list("RIGHT_RETURN_RIGHT_PB4_FAR_VIA" "GND" "TOP" list(62.6 25.65) "via") list("RIGHT_RETURN_RIGHT_PB5_MID_VIA" "GND" "TOP" list(56.757 25.092) "via") list("RIGHT_RETURN_RIGHT_PB5_FAR_VIA" "GND" "TOP" list(62.6 25.65) "via") list("RIGHT_RETURN_RIGHT_PB8_MID_VIA" "GND" "TOP" list(58.55 28.729) "via") list("RIGHT_RETURN_RIGHT_PB8_FAR_VIA" "GND" "TOP" list(63.55 27.171) "via") list("RIGHT_RETURN_RIGHT_SWO_FAR_VIA" "GND" "TOP" list(53.844 22.614) "via") list("HI_2L_I2C_SCL_1_R1" "I2C_SCL" "TOP" list(58.5 35.0) "point") list("HI_2L_I2C_SDA_1_R1" "I2C_SDA" "TOP" list(58.5 37.0) "point") list("RIGHT_SWCLK_TOP_WEST_BRIDGE" "SWCLK" "TOP" list(46.2 24.15) "point") list("RIGHT_SWCLK_WEST_BRIDGE_V" "SWCLK" "TOP" list(47.95 22.4) "via") list("RIGHT_SWCLK_BOTTOM_BRIDGE" "SWCLK" "BOTTOM" list(47.95 22.4) "point") list("RIGHT_SWCLK_EAST_BRIDGE_V" "SWCLK" "TOP" list(57.4 20.8) "via") list("RIGHT_SWCLK_TOP_EAST_BRIDGE" "SWCLK" "TOP" list(57.4 20.8) "point") list("RIGHT_SWCLK_WEST_RETURN" "GND" "TOP" list(46.8 22.5) "via") list("RIGHT_SWCLK_EAST_RETURN" "GND" "TOP" list(57.35 19.31) "via") list("RIGHT_SWCLK_MID_RETURN" "GND" "TOP" list(52.8 22.8) "via") list("HI_2L_BOOT_SERVICE_1_V1" "BOOT_SERVICE" "TOP" list(57.4 33.4) "via") list("HI_2L_BOOT_SERVICE_1_R1" "BOOT_SERVICE" "TOP" list(56.7 32.6764) "point") list("HI_2L_BOOT_SERVICE_1_R2" "BOOT_SERVICE" "BOTTOM" list(57.4 33.4) "point") list("HI_2L_BOOT1_1_V2" "BOOT1" "TOP" list(32.35 23.85) "via") list("HI_2L_BOOT1_1_R3" "BOOT1" "TOP" list(32.35 23.85) "point") list("HI_2L_CAN_TXD_1_V1" "CAN_TXD" "TOP" list(47.7 18.3) "via") list("HI_2L_CAN_TXD_1_V2" "CAN_TXD" "TOP" list(50.25 18.3) "via") list("HI_2L_CAN_TXD_1_R1" "CAN_TXD" "TOP" list(44.4764 18.3) "point") list("HI_2L_CAN_TXD_1_R2" "CAN_TXD" "BOTTOM" list(47.7 18.3) "point") list("HI_2L_CAN_TXD_1_R3" "CAN_TXD" "TOP" list(50.25 18.3) "point") list("LEFT_BOOT1_BOTTOM_RESHAPE" "BOOT1" "BOTTOM" list(34.4 26.0) "point") list("ROOT_SWDIO_BOTTOM" "SWDIO" "BOTTOM" list(41.52 21.25) "point") list("ROOT_SWDIO_EAST_V" "SWDIO" "TOP" list(44.4 21.95) "via") list("ROOT_SWDIO_TOP" "SWDIO" "TOP" list(44.4 21.95) "point") list("ROOT_UART_RX_BOTTOM" "PA10_UART_RX" "BOTTOM" list(40.0 20.5) "point") list("ROOT_UART_RX_EAST_V" "PA10_UART_RX" "TOP" list(50.1 22.4) "via") list("ROOT_UART_RX_TOP" "PA10_UART_RX" "TOP" list(50.1 22.4) "point") list("ROOT_UART_TX_BOTTOM" "PA9_UART_TX" "BOTTOM" list(39.7 21.7) "point") list("ROOT_UART_TX_EAST_V" "PA9_UART_TX" "TOP" list(46.3 21.1) "via") list("ROOT_UART_TX_TOP" "PA9_UART_TX" "TOP" list(46.3 21.1) "point") list("ROOT_ATTACH_BOTTOM" "USB_ATTACH_N" "BOTTOM" list(39.0 21.2) "point") list("ROOT_SWDIO_RETURN_COMMON" "GND" "TOP" list(45.3 22.55) "via") list("NODE_JS_1" "GPIO_PB12" "TOP" list(37.0 21.25) "via") list("NODE_JS_2" "GPIO_PB13" "TOP" list(37.5 20.75) "via") list("NODE_JS_3" "GPIO_PB14" "TOP" list(38.0 21.25) "via") list("NODE_JS_4" "GPIO_PB15" "TOP" list(38.5 20.7) "via") list("NODE_JS_5" "SWCLK" "TOP" list(46.2 24.15) "point") list("NODE_JS_6" "GPIO_PA15" "TOP" list(46.8 24.65) "point") list("NODE_JS_7" "SWO" "BOTTOM" list(46.8 25.15) "point") list("NODE_JS_8" "GPIO_PB4" "TOP" list(46.8 25.65) "point") list("NODE_JS_9" "GPIO_PB5" "BOTTOM" list(46.8 26.15) "point") list("NODE_JS_10" "I2C_SCL" "TOP" list(46.8 26.65) "point") list("NODE_JS_11" "I2C_SDA" "BOTTOM" list(46.8 27.15) "point") list("NODE_JS_12" "BOOT0" "TOP" list(46.8 27.65) "point") list("NODE_JS_13" "GPIO_PB8" "BOTTOM" list(46.8 28.15) "point") list("NODE_JS_14" "GPIO_PB9" "BOTTOM" list(46.8 28.65) "point") list("B016_NODE_175" "GPIO_PB10" "TOP" list(38.0 26.3) "via") list("RETAINED_SOUTH_REAL_SOURCE_0" "GPIO_PB12" "TOP" list(37.0 21.25) "via") list("RETAINED_SOUTH_REAL_SOURCE_1" "GPIO_PB13" "TOP" list(37.5 20.75) "via") list("RETAINED_SOUTH_REAL_SOURCE_2" "GPIO_PB14" "TOP" list(38.0 21.25) "via") list("RETAINED_SOUTH_REAL_SOURCE_3" "GPIO_PB15" "TOP" list(38.5 20.7) "via") list("NORTH_KEEP_EXISTING_0" "GPIO_PC13" "TOP" list(42.0 28.9) "via") list("NORTH_KEEP_EXISTING_1" "GPIO_PC15" "TOP" list(40.3 28.9) "via") list("NORTH_KEEP_EXISTING_2" "GPIO_PA1" "TOP" list(37.5 29.6) "via") list("NORTH_KEEP_EXISTING_3" "GPIO_PA2" "TOP" list(36.6 30.4) "via") list("NORTH_KEEP_EXISTING_4" "GPIO_PA3" "TOP" list(35.2 31.65) "via") list("NORTH_KEEP_EXISTING_5" "GND" "TOP" list(48.2 25.0) "via") list("B018_ALL_REAL_GND_VIA_0" "GND" "TOP" list(41.0 4.7) "via") list("B018_ALL_REAL_GND_VIA_1" "GND" "TOP" list(38.3 5.6) "via") list("B018_ALL_REAL_GND_VIA_2" "GND" "TOP" list(46.907 6.675) "via") list("B018_ALL_REAL_GND_VIA_3" "GND" "TOP" list(22.152 13.45) "via") list("B018_ALL_REAL_GND_VIA_4" "GND" "TOP" list(22.152 14.25) "via") list("B018_ALL_REAL_GND_VIA_5" "GND" "TOP" list(36.077 8.725) "via") list("B018_ALL_REAL_GND_VIA_6" "GND" "TOP" list(36.1 11.6764) "via") list("B018_ALL_REAL_GND_VIA_7" "GND" "TOP" list(40.0 11.4) "via") list("B018_ALL_REAL_GND_VIA_8" "GND" "TOP" list(40.5 11.6) "via") list("B018_ALL_REAL_GND_VIA_9" "GND" "TOP" list(47.0 13.45) "via") list("B018_ALL_REAL_GND_VIA_10" "GND" "TOP" list(43.8 10.7764) "via") list("B018_ALL_REAL_GND_VIA_11" "GND" "TOP" list(43.8 11.5764) "via") list("B018_ALL_REAL_GND_VIA_12" "GND" "TOP" list(50.95 12.5) "via") list("B018_ALL_REAL_GND_VIA_13" "GND" "TOP" list(61.7 11.2) "via") list("B018_ALL_REAL_GND_VIA_14" "GND" "TOP" list(60.8 15.8348) "via") list("B018_ALL_REAL_GND_VIA_15" "GND" "TOP" list(62.6 14.73) "via") list("B018_ALL_REAL_GND_VIA_16" "GND" "TOP" list(16.5 15.5) "via") list("B018_ALL_REAL_GND_VIA_17" "GND" "TOP" list(13.8 18.3) "via") list("B018_ALL_REAL_GND_VIA_18" "GND" "TOP" list(23.2 18.8) "via") list("B018_ALL_REAL_GND_VIA_19" "GND" "TOP" list(23.2 18.0) "via") list("B018_ALL_REAL_GND_VIA_20" "GND" "TOP" list(35.2 18.5) "via") list("B018_ALL_REAL_GND_VIA_21" "GND" "TOP" list(34.25 17.25) "via") list("B018_ALL_REAL_GND_VIA_22" "GND" "TOP" list(35.8 21.95) "via") list("B018_ALL_REAL_GND_VIA_23" "GND" "TOP" list(31.0 21.6) "via") list("B018_ALL_REAL_GND_VIA_24" "GND" "TOP" list(38.8 19.7) "via") list("B018_ALL_REAL_GND_VIA_25" "GND" "TOP" list(38.0 20.0) "via") list("B018_ALL_REAL_GND_VIA_26" "GND" "TOP" list(42.3252 19.35) "via") list("B018_ALL_REAL_GND_VIA_27" "GND" "TOP" list(54.75 19.75) "via") list("B018_ALL_REAL_GND_VIA_28" "GND" "TOP" list(51.411 17.028) "via") list("B018_ALL_REAL_GND_VIA_29" "GND" "TOP" list(57.35 19.31) "via") list("B018_ALL_REAL_GND_VIA_30" "GND" "TOP" list(13.0 27.0) "via") list("B018_ALL_REAL_GND_VIA_31" "GND" "TOP" list(13.0 26.148) "via") list("B018_ALL_REAL_GND_VIA_32" "GND" "TOP" list(38.0 25.27) "via") list("B018_ALL_REAL_GND_VIA_33" "GND" "TOP" list(32.45 25.2748) "via") list("B018_ALL_REAL_GND_VIA_34" "GND" "TOP" list(28.6 29.0) "via") list("B018_ALL_REAL_GND_VIA_35" "GND" "TOP" list(27.9 29.0) "via") list("B018_ALL_REAL_GND_VIA_36" "GND" "TOP" list(28.2236 22.4) "via") list("B018_ALL_REAL_GND_VIA_37" "GND" "TOP" list(24.2 27.0) "via") list("B018_ALL_REAL_GND_VIA_38" "GND" "TOP" list(24.2 27.8) "via") list("B018_ALL_REAL_GND_VIA_39" "GND" "TOP" list(23.7 23.35) "via") list("B018_ALL_REAL_GND_VIA_40" "GND" "TOP" list(23.7 22.55) "via") list("B018_ALL_REAL_GND_VIA_41" "GND" "TOP" list(32.85 28.1) "via") list("B018_ALL_REAL_GND_VIA_42" "GND" "TOP" list(32.8 25.3) "via") list("B018_ALL_REAL_GND_VIA_43" "GND" "TOP" list(30.9 29.1) "via") list("B018_ALL_REAL_GND_VIA_44" "GND" "TOP" list(39.5 28.0) "via") list("B018_ALL_REAL_GND_VIA_45" "GND" "TOP" list(37.4 27.4) "via") list("B018_ALL_REAL_GND_VIA_46" "GND" "TOP" list(39.8 27.3) "via") list("B018_ALL_REAL_GND_VIA_47" "GND" "TOP" list(42.0 27.9) "via") list("B018_ALL_REAL_GND_VIA_48" "GND" "TOP" list(45.3 22.55) "via") list("B018_ALL_REAL_GND_VIA_49" "GND" "TOP" list(46.8 22.5) "via") list("B018_ALL_REAL_GND_VIA_50" "GND" "TOP" list(48.25 28.7252) "via") list("B018_ALL_REAL_GND_VIA_51" "GND" "TOP" list(37.7 37.7) "via") list("B018_ALL_REAL_GND_VIA_52" "GND" "TOP" list(47.1 35.5748) "via") list("B018_ALL_REAL_GND_VIA_53" "GND" "TOP" list(46.35 29.4) "via") list("B018_ALL_REAL_GND_VIA_54" "GND" "TOP" list(48.2 25.0) "via") list("B018_ALL_REAL_GND_VIA_55" "GND" "TOP" list(52.8 22.8) "via") list("B018_ALL_REAL_GND_VIA_56" "GND" "TOP" list(53.844 22.614) "via") list("B018_ALL_REAL_GND_VIA_57" "GND" "TOP" list(56.757 25.092) "via") list("B018_ALL_REAL_GND_VIA_58" "GND" "TOP" list(51.3 29.2) "via") list("B018_ALL_REAL_GND_VIA_59" "GND" "TOP" list(63.55 27.171) "via") list("B018_ALL_REAL_GND_VIA_60" "GND" "TOP" list(58.55 28.729) "via") list("B018_ALL_REAL_GND_VIA_61" "GND" "TOP" list(62.6 25.65) "via") list("B018_ALL_REAL_GND_VIA_62" "GND" "TOP" list(61.0 23.35) "via") list("B018_ALL_REAL_GND_VIA_63" "GND" "TOP" list(14.0 30.6) "via") list("B018_ALL_REAL_GND_VIA_64" "GND" "TOP" list(27.1 31.55) "via") list("B018_ALL_REAL_GND_VIA_65" "GND" "TOP" list(21.0 31.55) "via") list("B018_ALL_REAL_GND_VIA_66" "GND" "TOP" list(20.8 33.75) "via") list("B018_ALL_REAL_GND_VIA_67" "GND" "TOP" list(20.5 29.32) "via") list("B018_ALL_REAL_GND_VIA_68" "GND" "TOP" list(29.0 33.2) "via") list("B018_ALL_REAL_GND_VIA_69" "GND" "TOP" list(34.4 35.7) "via") list("B018_ALL_REAL_GND_VIA_70" "GND" "TOP" list(36.95 36.25) "via") list("B018_ALL_REAL_GND_VIA_71" "GND" "TOP" list(37.9 34.7748) "via") list("B018_ALL_REAL_GND_VIA_72" "GND" "TOP" list(38.7 29.5) "via") list("B018_ALL_REAL_GND_VIA_73" "GND" "TOP" list(48.9 32.4) "via") list("B018_ALL_REAL_GND_VIA_74" "GND" "TOP" list(52.0 35.0) "via") list("B018_ALL_REAL_GND_VIA_75" "GND" "TOP" list(32.2 40.1) "via") list("B018_ALL_REAL_GND_VIA_76" "GND" "TOP" list(34.8 39.7) "via") list("B018_ALL_REAL_GND_VIA_77" "GND" "TOP" list(39.55 42.8) "via") list("B018_ALL_REAL_GND_VIA_78" "GND" "TOP" list(43.2 40.8) "via") list("B018_ALL_REAL_GND_VIA_79" "GND" "TOP" list(59.374 37.785) "via") list("B018_ALL_REAL_GND_VIA_80" "GND" "TOP" list(41.4 28.15) "via") list("B018_ALL_REAL_GND_VIA_81" "GND" "TOP" list(30.05 40.25) "via") list("B018_ALL_REAL_GND_VIA_82" "GND" "TOP" list(16.95 53.25) "via") list("B018_ALL_REAL_GND_VIA_83" "GND" "TOP" list(20.5 50.25) "via"))
    hiDiagnosticOutput="D:/001DIY/005lib/01AIEDA/learning/examples/lessonHI_38_50_20261021/logs/TOP_trial_2L_b018_DRC_PENDING_try01"
    hiDiagnosticLibrary="D:/001DIY/005lib/01AIEDA/learning/examples/lessonHI_38_50_20261021/library"
    axlSetVariable("padpath" list("D:/001DIY/005lib/01AIEDA/learning/examples/lessonHI_38_50_20261021/library"))
    axlSetVariable("psmpath" list("D:/001DIY/005lib/01AIEDA/learning/examples/lessonHI_38_50_20261021/library"))
    unless(axlLoadPadstack("L28_VIA030_C060") error("Cannot load isolated concrete via padstack\n"))
    hiDeleteExactBatch(f list(list("deleteVia" "N49_PC14_OLD_SOURCE_VIA" "GPIO_PC14" "" list(41.0 27.8) "L28_VIA030_C060") list("deleteVia" "N37_RIP_PC14_REMOTE_VIA" "GPIO_PC14" "" list(49.2 25.2) "L28_VIA030_C060") list("deleteSegment" "N37_RIP_GPIO_PC13_0" "GPIO_PC13" "BOTTOM" list(list(42.0 31.1) list(35.8 31.1)) 0.2) list("deleteSegment" "N37_RIP_GPIO_PC13_1" "GPIO_PC13" "BOTTOM" list(list(42.0 28.9) list(42.0 31.1)) 0.2) list("deleteSegment" "N37_RIP_GPIO_PC15_2" "GPIO_PC15" "BOTTOM" list(list(40.3 28.9) list(40.15 28.75)) 0.2) list("deleteSegment" "N37_RIP_GPIO_PC15_3" "GPIO_PC15" "BOTTOM" list(list(40.15 28.75) list(35.4 28.75)) 0.2) list("deleteSegment" "N37_RIP_GPIO_PC14_4" "GPIO_PC14" "BOTTOM" list(list(44.2 24.6) list(41.0 27.8)) 0.2) list("deleteSegment" "N37_RIP_GPIO_PC14_5" "GPIO_PC14" "BOTTOM" list(list(44.2 23.7) list(44.2 24.6)) 0.2) list("deleteSegment" "N37_RIP_GPIO_PC14_6" "GPIO_PC14" "BOTTOM" list(list(49.2 23.7) list(44.2 23.7)) 0.2) list("deleteSegment" "N37_RIP_GPIO_PC14_7" "GPIO_PC14" "BOTTOM" list(list(49.2 25.2) list(49.2 23.7)) 0.2) list("deleteSegment" "N49_PC14_OLD_TOP_9" "GPIO_PC14" "TOP" list(list(41.0 29.8) list(41.0 27.8)) 0.2) list("deleteSegment" "N49_PC14_OLD_TOP_10" "GPIO_PC14" "TOP" list(list(41.75 29.8) list(41.0 29.8)) 0.2) list("deleteSegment" "N49_PC14_OLD_TOP_11" "GPIO_PC14" "TOP" list(list(41.75 31.25) list(41.75 29.8)) 0.2)))
    hiDeferReference(f "B017_APP_REFERENCE_0" "BOTTOM" list(list(77.793 0.5) list(79.5 2.207) list(79.5 57.793) list(77.793 59.5) list(2.207 59.5) list(0.5 57.793) list(0.5 2.207) list(2.207 0.5)))
    hiDeferReference(f "B017_APP_REFERENCE_1" "TOP" list(list(37.7 4.3) list(42.2 4.3) list(42.2 6.6) list(37.7 6.6)))
    hiDeferReference(f "B017_APP_REFERENCE_2" "TOP" list(list(40.25 31.6) list(40.25 31.9) list(35.8 31.9) list(35.8 27.0) list(42.4 27.0) list(42.4 31.6)))
    hiDeferReference(f "B017_APP_REFERENCE_3" "TOP" list(list(47.5 28.4) list(39.2 28.4) list(39.2 24.6) list(47.5 24.6)))
    hiRoute(f "N50_2L_N49_GPIO_PC13_ACCESS" "GPIO_PC13" "BOTTOM" list(list(42.0 28.9) list(41.3 28.9) list(35.25 34.95) list(34.05 34.95)) list(0.2 0.2 0.2))
    hiRoute(f "N50_2L_N49_GPIO_PC15_ACCESS" "GPIO_PC15" "BOTTOM" list(list(40.3 28.9) list(40.3 29.0) list(34.8 34.5) list(33.55 34.5)) list(0.2 0.2 0.2))
    hiRoute(f "N50_2L_N49_GPIO_PA1_ACCESS" "GPIO_PA1" "BOTTOM" list(list(37.5 29.6) list(37.5 30.95) list(34.4 34.05) list(33.25 34.05)) list(0.2 0.2 0.2))
    hiRoute(f "N50_2L_N49_GPIO_PA2_ACCESS" "GPIO_PA2" "BOTTOM" list(list(36.6 30.4) list(36.6 31.25) list(34.25 33.6) list(33.0 33.6)) list(0.2 0.2 0.2))
    hiRoute(f "N50_2L_N49_GPIO_PA3_ACCESS" "GPIO_PA3" "BOTTOM" list(list(35.2 31.65) list(35.4 31.85) list(34.1 33.15) list(32.75 33.15)) list(0.2 0.2 0.2))
    hiRoute(f "N50_2L_N49_PC14_TOP_TEMP" "GPIO_PC14" "TOP" list(list(41.75 31.25) list(41.75 30.1) list(41.5 29.85) list(41.5 29.65)) list(0.2 0.2 0.2))
    hiVia(f "N50_2L_N49_PC14_VIA" "GPIO_PC14" list(41.5 29.65) "L28_VIA030_C060")
    hiRoute(f "N50_2L_N49_PC14_ACCESS" "GPIO_PC14" "BOTTOM" list(list(41.5 29.65) list(35.05 36.1)) list(0.2))
    hiVia(f "N50_2L_HI_2L_GPIO_PC13_1_V1" "GPIO_PC13" list(29.45 39.55) "L28_VIA030_C060")
    hiRoute(f "N50_2L_HI_2L_GPIO_PC13_1_R1" "GPIO_PC13" "BOTTOM" list(list(34.05 34.95) list(29.45 39.55)) list(0.2))
    hiRoute(f "N50_2L_HI_2L_GPIO_PC13_1_R2" "GPIO_PC13" "TOP" list(list(29.45 39.55) list(29.45 39.75) list(14.2 55.0) list(14.19 55.0)) list(0.2 0.2 0.2))
    hiVia(f "N50_2L_HI_2L_GPIO_PC14_1_V1" "GPIO_PC14" list(31.25 39.9) "L28_VIA030_C060")
    hiRoute(f "N50_2L_HI_2L_GPIO_PC14_1_R1" "GPIO_PC14" "BOTTOM" list(list(35.05 36.1) list(31.25 39.9)) list(0.2))
    hiRoute(f "N50_2L_HI_2L_GPIO_PC14_1_R2" "GPIO_PC14" "TOP" list(list(31.25 39.9) list(31.25 40.5) list(16.75 55.0) list(16.73 55.0)) list(0.2 0.2 0.2))
    hiRoute(f "N50_2L_HI_2L_GPIO_PC15_1_R1" "GPIO_PC15" "BOTTOM" list(list(33.55 34.5) list(19.25 48.8) list(19.25 55.0) list(19.27 55.0)) list(0.2 0.2 0.2))
    hiRoute(f "N50_2L_HI_2L_GPIO_PA1_1_R1" "GPIO_PA1" "BOTTOM" list(list(33.25 34.05) list(33.25 34.15) list(18.2 49.2) list(18.2 55.9) list(18.35 56.05) list(20.75 56.05) list(21.8 55.0) list(21.81 55.0)) list(0.2 0.2 0.2 0.2 0.2 0.2 0.2))
    hiVia(f "N50_2L_HI_2L_GPIO_PA2_1_V1" "GPIO_PA2" list(17.55 52.55) "L28_VIA030_C060")
    hiVia(f "N50_2L_HI_2L_GPIO_PA2_1_V2" "GPIO_PA2" list(19.9 50.95) "L28_VIA030_C060")
    hiRoute(f "N50_2L_HI_2L_GPIO_PA2_1_R1" "GPIO_PA2" "BOTTOM" list(list(33.0 33.6) list(17.55 49.05) list(17.55 52.55)) list(0.2 0.2))
    hiRoute(f "N50_2L_HI_2L_GPIO_PA2_1_R2" "GPIO_PA2" "TOP" list(list(17.55 52.55) list(18.3 52.55) list(19.9 50.95)) list(0.2 0.2))
    hiRoute(f "N50_2L_HI_2L_GPIO_PA2_1_R3" "GPIO_PA2" "BOTTOM" list(list(19.9 50.95) list(20.3 50.95) list(24.35 55.0)) list(0.2 0.2))
    hiRoute(f "N50_2L_HI_2L_GPIO_PA3_1_R1" "GPIO_PA3" "BOTTOM" list(list(32.75 33.15) list(15.65 50.25) list(15.65 55.9) list(16.25 56.5) list(25.4 56.5) list(26.9 55.0) list(26.89 55.0)) list(0.2 0.2 0.2 0.2 0.2 0.2))
    hiVia(f "N50_2L_RETURN_1" "GND" list(41.4 28.15) "L28_VIA030_C060")
    hiVia(f "N50_2L_RETURN_2" "GND" list(30.05 40.25) "L28_VIA030_C060")
    hiVia(f "N50_2L_RETURN_3" "GND" list(16.95 53.25) "L28_VIA030_C060")
    hiVia(f "N50_2L_RETURN_4" "GND" list(20.5 50.25) "L28_VIA030_C060")
    hiRestoreReference(f "B017_APP_REFERENCE_0")
    hiShape(f "B018_APP_TOP_TRIAL" "GND" "TOP" list(list(77.793 0.5) list(79.5 2.207) list(79.5 57.793) list(77.793 59.5) list(2.207 59.5) list(0.5 57.793) list(0.5 2.207) list(2.207 0.5)) t list(list(list(46.55 32.85) list(46.55 31.895) list(47.05 31.395) list(47.05 28.95) list(45.65 28.95) list(45.65 31.105) list(45.155 31.6) list(40.25 31.6) list(40.25 32.45) list(39.65 32.45) list(39.65 36.45) list(36.85 36.45) list(36.85 37.1) list(36.4 37.1) list(36.4 40.4) list(42.2 40.4) list(42.8 40.4) list(42.8 39.75) list(43.6 39.75) list(43.6 40.4) list(48.4 40.4) list(48.4 36.1748) list(48.4 34.9748) list(48.4 33.5) list(48.4 32.9) list(47.85 32.9) list(47.85 32.85))))
    hiRetireReplacedTopReferences(f)
    hiVerifyReferences(f)
    hiPhysicalTerminalContract(f list(list("J2" "SH4" "GND" "L10_USB4105_SLOT060X140") list("J2" "SH3" "GND" "L10_USB4105_SLOT060X140") list("J2" "SH2" "GND" "L10_USB4105_SLOT060X170") list("J2" "SH1" "GND" "L10_USB4105_SLOT060X170") list("J2" "B1_A12" "GND" "L10_USB4105_SMD060X115") list("J2" "B4_A9" "USB_VBUS" "L10_USB4105_SMD060X115") list("J2" "B5" "USB_CC2" "L10_USB4105_SMD030X115") list("J2" "A8" nil "L10_USB4105_SMD030X115") list("J2" "B6" "USB_DP" "L10_USB4105_SMD030X115") list("J2" "A7" "USB_DM" "L10_USB4105_SMD030X115") list("J2" "A6" "USB_DP" "L10_USB4105_SMD030X115") list("J2" "B7" "USB_DM" "L10_USB4105_SMD030X115") list("J2" "A5" "USB_CC1" "L10_USB4105_SMD030X115") list("J2" "B8" nil "L10_USB4105_SMD030X115") list("J2" "A4_B9" "USB_VBUS" "L10_USB4105_SMD060X115") list("J2" "A1_B12" "GND" "L10_USB4105_SMD060X115") list("J3" "3" "GND" "VIA_1D0_1D54") list("J3" "2" "CAN_L" "VIA_1D0_1D54") list("J3" "1" "CAN_H" "VIA_1D0_1D54S") list("J4" "4" "GND" "VIA_1D0_1D54") list("J4" "3" "UART_RX" "VIA_1D0_1D54") list("J4" "2" "UART_TX" "VIA_1D0_1D54") list("J4" "1" "V3V3" "VIA_1D0_1D54S") list("J5" "4" "GND" "VIA_1D0_1D54") list("J5" "3" "I2C_SDA" "VIA_1D0_1D54") list("J5" "2" "I2C_SCL" "VIA_1D0_1D54") list("J5" "1" "V3V3" "VIA_1D0_1D54S") list("J6" "6" "GND" "VIAS_30_CIRCLE") list("J6" "5" "SPI_NSS" "VIAS_30_CIRCLE") list("J6" "4" "SPI_MISO" "VIAS_30_CIRCLE") list("J6" "3" "SPI_MOSI" "VIAS_30_CIRCLE") list("J6" "2" "SPI_SCK" "VIAS_30_CIRCLE") list("J6" "1" "V3V3" "VIAS_30_SQUARE") list("J9" "6" "SWO" "VIAS_30_CIRCLE") list("J9" "5" "NRST" "VIAS_30_CIRCLE") list("J9" "4" "SWCLK" "VIAS_30_CIRCLE") list("J9" "3" "SWDIO" "VIAS_30_CIRCLE") list("J9" "2" "GND" "VIAS_30_CIRCLE") list("J9" "1" "V3V3" "VIAS_30_SQUARE") list("J11" "8" "GPIO_PA3" "VIA_1D0_1D54") list("J11" "7" "GPIO_PA2" "VIA_1D0_1D54") list("J11" "6" "GPIO_PA1" "VIA_1D0_1D54") list("J11" "5" "GPIO_PC15" "VIA_1D0_1D54") list("J11" "4" "GPIO_PC14" "VIA_1D0_1D54") list("J11" "3" "GPIO_PC13" "VIA_1D0_1D54") list("J11" "2" "GND" "VIA_1D0_1D54") list("J11" "1" "V3V3" "VIA_1D0_1D54S") list("J12" "8" "GPIO_PB14" "VIA_1D0_1D54") list("J12" "7" "GPIO_PB13" "VIA_1D0_1D54") list("J12" "6" "GPIO_PB12" "VIA_1D0_1D54") list("J12" "5" "GPIO_PB11" "VIA_1D0_1D54") list("J12" "4" "GPIO_PB10" "VIA_1D0_1D54") list("J12" "3" "GPIO_PB1" "VIA_1D0_1D54") list("J12" "2" "GND" "VIA_1D0_1D54") list("J12" "1" "V3V3" "VIA_1D0_1D54S") list("J13" "8" "GPIO_PB9" "VIA_1D0_1D54") list("J13" "7" "GPIO_PB8" "VIA_1D0_1D54") list("J13" "6" "GPIO_PB5" "VIA_1D0_1D54") list("J13" "5" "GPIO_PB4" "VIA_1D0_1D54") list("J13" "4" "GPIO_PA15" "VIA_1D0_1D54") list("J13" "3" "GPIO_PB15" "VIA_1D0_1D54") list("J13" "2" "GND" "VIA_1D0_1D54") list("J13" "1" "V3V3" "VIA_1D0_1D54S") list("R23" "1" "PA4_SPI_NSS" "SMD_37X32RET") list("R23" "2" "SPI_NSS" "SMD_37X32RET") list("R21" "1" "PA5_SPI_SCK" "SMD_37X32RET") list("R21" "2" "SPI_SCK" "SMD_37X32RET") list("R24" "1" "PA6_SPI_MISO" "SMD_37X32RET") list("R24" "2" "SPI_MISO" "SMD_37X32RET") list("R22" "1" "PA7_SPI_MOSI" "SMD_37X32RET") list("R22" "2" "SPI_MOSI" "SMD_37X32RET") list("R25" "1" "V3V3" "SMD_37X32RET") list("R25" "2" "PA4_SPI_NSS" "SMD_37X32RET") list("R19" "1" "V3V3" "SMD_37X32RET") list("R19" "2" "I2C_SCL" "SMD_37X32RET") list("R20" "1" "V3V3" "SMD_37X32RET") list("R20" "2" "I2C_SDA" "SMD_37X32RET") list("C13" "1" "V3V3" "SMD_37X32RET") list("C13" "2" "GND" "SMD_37X32RET") list("C14" "1" "V3V3" "SMD_37X32RET") list("C14" "2" "GND" "SMD_37X32RET") list("C15" "1" "V3V3" "SMD_37X32RET") list("C15" "2" "GND" "SMD_37X32RET") list("C17" "1" "V3V3" "SMD_37X32RET") list("C17" "2" "GND" "SMD_37X32RET") list("C18" "1" "VDDA" "SMD_37X32RET") list("C18" "2" "GND" "SMD_37X32RET") list("C19" "1" "VDDA" "SMD_37X32RET") list("C19" "2" "GND" "SMD_37X32RET") list("C21" "1" "NRST" "SMD_37X32RET") list("C21" "2" "GND" "SMD_37X32RET") list("C22" "1" "OSC_IN" "SMD_37X32RET") list("C22" "2" "GND" "SMD_37X32RET") list("C23" "1" "XTAL_OUT" "SMD_37X32RET") list("C23" "2" "GND" "SMD_37X32RET") list("C24" "1" "ADC0" "SMD_37X32RET") list("C24" "2" "GND" "SMD_37X32RET") list("R26" "1" "V3V3" "SMD_37X32RET") list("R26" "2" "VDDA" "SMD_37X32RET") list("R27" "1" "V3V3" "SMD_37X32RET") list("R27" "2" "NRST" "SMD_37X32RET") list("R28" "1" "BOOT0" "SMD_37X32RET") list("R28" "2" "GND" "SMD_37X32RET") list("R29" "1" "BOOT1" "SMD_37X32RET") list("R29" "2" "GND" "SMD_37X32RET") list("R30" "1" "V3V3" "SMD_37X32RET") list("R30" "2" "BOOT_SERVICE" "SMD_37X32RET") list("R31" "1" "OSC_OUT" "SMD_37X32RET") list("R31" "2" "XTAL_OUT" "SMD_37X32RET") list("R32" "1" "ADC_IN" "SMD_37X32RET") list("R32" "2" "ADC0" "SMD_37X32RET") list("F1" "1" "VIN_RAW" "SMD_37X32RET") list("F1" "2" "VIN_FUSED" "SMD_37X32RET") list("C3" "1" "VIN_PROT" "SMD_37X32RET") list("C3" "2" "GND" "SMD_37X32RET") list("C4" "1" "BUCK_BOOT" "SMD_37X32RET") list("C4" "2" "BUCK_SW" "SMD_37X32RET") list("R1" "1" "V5" "SMD_37X32RET") list("R1" "2" "BUCK_FB" "SMD_37X32RET") list("R2" "1" "BUCK_FB" "SMD_37X32RET") list("R2" "2" "GND" "SMD_37X32RET") list("C7" "1" "V5" "SMD_37X32RET") list("C7" "2" "BUCK_FB" "SMD_37X32RET") list("C10" "1" "USB_VBUS" "SMD_37X32RET") list("C10" "2" "GND" "SMD_37X32RET") list("R3" "1" "USB_CC1" "SMD_37X32RET") list("R3" "2" "GND" "SMD_37X32RET") list("R4" "1" "USB_CC2" "SMD_37X32RET") list("R4" "2" "GND" "SMD_37X32RET") list("R5" "1" "PA12_SHARED" "SMD_37X32RET") list("R5" "2" "USB_DP" "SMD_37X32RET") list("R6" "1" "PA11_SHARED" "SMD_37X32RET") list("R6" "2" "USB_DM" "SMD_37X32RET") list("R7" "1" "USB_VBUS" "SMD_37X32RET") list("R7" "2" "VBUS_GATE" "SMD_37X32RET") list("R8" "1" "VBUS_GATE" "SMD_37X32RET") list("R8" "2" "GND" "SMD_37X32RET") list("R9" "1" "V3V3" "SMD_37X32RET") list("R9" "2" "VBUS_PRESENT_N" "SMD_37X32RET") list("R10" "1" "V3V3" "SMD_37X32RET") list("R10" "2" "USB_ATTACH_N" "SMD_37X32RET") list("R11" "1" "USB_PULLUP_SRC" "SMD_37X32RET") list("R11" "2" "USB_DP" "SMD_37X32RET") list("R12" "1" "PA12_SHARED" "SMD_37X32RET") list("R12" "2" "CAN_TXD" "SMD_37X32RET") list("R13" "1" "PA11_SHARED" "SMD_37X32RET") list("R13" "2" "CAN_RXD" "SMD_37X32RET") list("C11" "1" "V3V3" "SMD_37X32RET") list("C11" "2" "GND" "SMD_37X32RET") list("C12" "1" "V3V3" "SMD_37X32RET") list("C12" "2" "GND" "SMD_37X32RET") list("R14" "1" "V3V3" "SMD_37X32RET") list("R14" "2" "CAN_TXD" "SMD_37X32RET") list("R16" "1" "PA9_UART_TX" "SMD_37X32RET") list("R16" "2" "UART_TX" "SMD_37X32RET") list("R17" "1" "PA10_UART_RX" "SMD_37X32RET") list("R17" "2" "UART_RX" "SMD_37X32RET") list("R18" "1" "UART_RX" "SMD_37X32RET") list("R18" "2" "V3V3" "SMD_37X32RET") list("U1" "48" "V3V3" "L09_QFP120X030_M05") list("U1" "47" "GND" "L09_QFP120X030_M05") list("U1" "46" "GPIO_PB9" "L09_QFP120X030_M05") list("U1" "45" "GPIO_PB8" "L09_QFP120X030_M05") list("U1" "44" "BOOT0" "L09_QFP120X030_M05") list("U1" "43" "I2C_SDA" "L09_QFP120X030_M05") list("U1" "42" "I2C_SCL" "L09_QFP120X030_M05") list("U1" "41" "GPIO_PB5" "L09_QFP120X030_M05") list("U1" "40" "GPIO_PB4" "L09_QFP120X030_M05") list("U1" "39" "SWO" "L09_QFP120X030_M05") list("U1" "38" "GPIO_PA15" "L09_QFP120X030_M05") list("U1" "37" "SWCLK" "L09_QFP120X030_M05") list("U1" "36" "V3V3" "L09_QFP120X030_M05") list("U1" "35" "GND" "L09_QFP120X030_M05") list("U1" "34" "SWDIO" "L09_QFP120X030_M05") list("U1" "33" "PA12_SHARED" "L09_QFP120X030_M05") list("U1" "32" "PA11_SHARED" "L09_QFP120X030_M05") list("U1" "31" "PA10_UART_RX" "L09_QFP120X030_M05") list("U1" "30" "PA9_UART_TX" "L09_QFP120X030_M05") list("U1" "29" "USB_ATTACH_N" "L09_QFP120X030_M05") list("U1" "28" "GPIO_PB15" "L09_QFP120X030_M05") list("U1" "27" "GPIO_PB14" "L09_QFP120X030_M05") list("U1" "26" "GPIO_PB13" "L09_QFP120X030_M05") list("U1" "25" "GPIO_PB12" "L09_QFP120X030_M05") list("U1" "24" "V3V3" "L09_QFP120X030_M05") list("U1" "23" "GND" "L09_QFP120X030_M05") list("U1" "22" "GPIO_PB11" "L09_QFP120X030_M05") list("U1" "21" "GPIO_PB10" "L09_QFP120X030_M05") list("U1" "20" "BOOT1" "L09_QFP120X030_M05") list("U1" "19" "GPIO_PB1" "L09_QFP120X030_M05") list("U1" "18" "VBUS_PRESENT_N" "L09_QFP120X030_M05") list("U1" "17" "PA7_SPI_MOSI" "L09_QFP120X030_M05") list("U1" "16" "PA6_SPI_MISO" "L09_QFP120X030_M05") list("U1" "15" "PA5_SPI_SCK" "L09_QFP120X030_M05") list("U1" "14" "PA4_SPI_NSS" "L09_QFP120X030_M05") list("U1" "13" "GPIO_PA3" "L09_QFP120X030_M05") list("U1" "12" "GPIO_PA2" "L09_QFP120X030_M05") list("U1" "11" "GPIO_PA1" "L09_QFP120X030_M05") list("U1" "10" "ADC0" "L09_QFP120X030_M05") list("U1" "9" "VDDA" "L09_QFP120X030_M05") list("U1" "8" "GND" "L09_QFP120X030_M05") list("U1" "7" "NRST" "L09_QFP120X030_M05") list("U1" "6" "OSC_OUT" "L09_QFP120X030_M05") list("U1" "5" "OSC_IN" "L09_QFP120X030_M05") list("U1" "4" "GPIO_PC15" "L09_QFP120X030_M05") list("U1" "3" "GPIO_PC14" "L09_QFP120X030_M05") list("U1" "2" "GPIO_PC13" "L09_QFP120X030_M05") list("U1" "1" "V3V3" "L09_QFP120X030_M05") list("C16" "1" "V3V3" "SMD_40X50RET") list("C16" "2" "GND" "SMD_40X50RET") list("C20" "1" "VDDA" "SMD_40X50RET") list("C20" "2" "GND" "SMD_40X50RET") list("C8" "1" "V5" "SMD_40X50RET") list("C8" "2" "GND" "SMD_40X50RET") list("C9" "1" "V3V3" "SMD_40X50RET") list("C9" "2" "GND" "SMD_40X50RET") list("Y1" "4" "GND" "DE_SMD180X120") list("Y1" "3" "XTAL_OUT" "DE_SMD180X120") list("Y1" "2" "GND" "DE_SMD180X120") list("Y1" "1" "OSC_IN" "DE_SMD180X120") list("J7" "2" "GND" "VIA_1D0_1D54") list("J7" "1" "NRST" "VIA_1D0_1D54S") list("J8" "2" "BOOT0" "VIA_1D0_1D54") list("J8" "1" "BOOT_SERVICE" "VIA_1D0_1D54S") list("J10" "2" "GND" "VIA_1D0_1D54") list("J10" "1" "ADC_IN" "VIA_1D0_1D54S") list("J1" "2" "GND" "VIA_1D0_1D54") list("J1" "1" "VIN_RAW" "VIA_1D0_1D54S") list("D1" "2" "VIN_FUSED" "PAD67X78") list("D1" "1" "VIN_PROT" "PAD67X78") list("C1" "2" "GND" "VIA_1D0_1D54") list("C1" "1" "VIN_PROT" "VIA_1D0_1D54S") list("C2" "1" "VIN_PROT" "SMD_60X63RET") list("C2" "2" "GND" "SMD_60X63RET") list("C5" "1" "V5" "SMD_60X63RET") list("C5" "2" "GND" "SMD_60X63RET") list("C6" "1" "V5" "SMD_60X63RET") list("C6" "2" "GND" "SMD_60X63RET") list("R15" "1" "CAN_H" "SMD_60X63RET") list("R15" "2" "CAN_L" "SMD_60X63RET") list("U2" "6" "BUCK_BOOT" "PAD_0D6_1D1O") list("U2" "5" nil "PAD_0D6_1D1O") list("U2" "4" "BUCK_FB" "PAD_0D6_1D1O") list("U2" "3" "VIN_PROT" "PAD_0D6_1D1O") list("U2" "2" "BUCK_SW" "PAD_0D6_1D1O") list("U2" "1" "GND" "PAD_0D6_1D1O") list("U4" "6" "USB_DP" "PAD_0D6_1D1O") list("U4" "5" "USB_VBUS" "PAD_0D6_1D1O") list("U4" "4" "USB_DM" "PAD_0D6_1D1O") list("U4" "3" "USB_DM" "PAD_0D6_1D1O") list("U4" "2" "GND" "PAD_0D6_1D1O") list("U4" "1" "USB_DP" "PAD_0D6_1D1O") list("L1" "2" "V5" "DE_SMD143X550") list("L1" "1" "BUCK_SW" "DE_SMD143X550") list("U3" "1" "V5" "PAD_1D3_0D6") list("U3" "2" "GND" "PAD_1D3_0D6") list("U3" "3" "V5" "PAD_1D3_0D6") list("U3" "4" nil "PAD_1D3_0D6") list("U3" "5" "V3V3" "PAD_1D3_0D6") list("Q1" "1" "VBUS_GATE" "PAD_36_47") list("Q1" "2" "GND" "PAD_36_47") list("Q1" "3" "VBUS_PRESENT_N" "PAD_36_47") list("Q2" "1" "USB_ATTACH_N" "PAD_36_47") list("Q2" "2" "V3V3" "PAD_36_47") list("Q2" "3" "USB_PULLUP_SRC" "PAD_36_47") list("U5" "1" "CAN_TXD" "RE60X24") list("U5" "2" "GND" "RE60X24") list("U5" "3" "V3V3" "RE60X24") list("U5" "4" "CAN_RXD" "RE60X24") list("U5" "5" nil "RE60X24") list("U5" "6" "CAN_L" "RE60X24") list("U5" "7" "CAN_H" "RE60X24") list("U5" "8" nil "RE60X24")))
    hiVerifyExplicitPA10Restored(f)
    axlDBControl('drcEnable t)
    fprintf(f "HI_SCOPED_CHECK_MASTER_DRC_ENABLED=%L\n" axlDBControl('drcEnable))
    hiGroundTrialHealth("D:/001DIY/005lib/01AIEDA/learning/examples/lessonHI_38_50_20261021/logs/TOP_trial_2L_b018_DRC_PENDING_try01" 56 84)
    hiHSEIsolationChallengeGraph("D:/001DIY/005lib/01AIEDA/learning/examples/lessonHI_38_50_20261021/logs/TOP_trial_2L_b018_DRC_PENDING_try01" list(46.35 29.4) "BOTTOM" list(list(42.2 39.8) list(44.2 39.8) list(47.8 33.5)))
    hiGroundTrialHealth("D:/001DIY/005lib/01AIEDA/learning/examples/lessonHI_38_50_20261021/logs/TOP_trial_2L_b018_DRC_PENDING_try01" 56 84)
    hiScopedChangedNetworks("D:/001DIY/005lib/01AIEDA/learning/examples/lessonHI_38_50_20261021/logs/TOP_trial_2L_b018_DRC_PENDING_try01" list("ADC0" "ADC_IN" "BOOT0" "BOOT1" "BOOT_SERVICE" "BUCK_BOOT" "BUCK_FB" "BUCK_SW" "CAN_RXD" "CAN_TXD" "GND" "GPIO_PA1" "GPIO_PA15" "GPIO_PA2" "GPIO_PA3" "GPIO_PB1" "GPIO_PB10" "GPIO_PB11" "GPIO_PB12" "GPIO_PB13" "GPIO_PB14" "GPIO_PB15" "GPIO_PB4" "GPIO_PB5" "GPIO_PB8" "GPIO_PB9" "GPIO_PC13" "GPIO_PC14" "GPIO_PC15" "I2C_SCL" "I2C_SDA" "NRST" "OSC_IN" "OSC_OUT" "PA10_UART_RX" "PA4_SPI_NSS" "PA5_SPI_SCK" "PA6_SPI_MISO" "PA7_SPI_MOSI" "PA9_UART_TX" "SPI_MISO" "SPI_MOSI" "SPI_NSS" "SPI_SCK" "SWCLK" "SWDIO" "SWO" "UART_RX" "UART_TX" "USB_ATTACH_N" "USB_CC1" "USB_CC2" "USB_PULLUP_SRC" "USB_VBUS" "V3V3" "V5" "VBUS_GATE" "VBUS_PRESENT_N" "VDDA" "VIN_FUSED" "VIN_PROT" "VIN_RAW" "XTAL_OUT" "CAN_H" "CAN_L" "USB_DP" "USB_DM" "PA11_SHARED" "PA12_SHARED"))
    t)
   progn(
    axlDBControl('drcEnable t)
    fprintf(f "HI_UNWIND_DRC_RESTORED=%L\n" axlDBControl('drcEnable))))
  unless(axlDBControl('drcEnable) error("Final DRC must be enabled\n"))
  hiFinalize(f "D:/001DIY/005lib/01AIEDA/learning/examples/lessonHI_38_50_20261021/logs/TOP_trial_2L_b018_DRC_PENDING_try01" "D:/001DIY/005lib/01AIEDA/learning/examples/lessonHI_38_50_20261021/native_candidates/HI_2L_north6_TOP_trial_b018_DRC_PENDING.brd" "D:/001DIY/005lib/01AIEDA/learning/examples/lessonHI_38_50_20261021/library" list(list("U1.25" "SOUTH_SOURCE_25_VIA" t) list("U1.26" "SOUTH_SOURCE_26_VIA" t) list("U1.27" "SOUTH_SOURCE_27_VIA" t) list("U1.28" "SOUTH_SOURCE_28_VIA" t) list("U1.29" "SOUTH_SOURCE_29_VIA" t) list("U1.30" "SOUTH_SOURCE_30_VIA" t) list("U1.31" "SOUTH_SOURCE_31_VIA" t) list("U1.34" "SOUTH_SOURCE_34_VIA" t) list("U1.14" "R25.2" t) list("U1.35" "C14.2" t) list("U1.35" "U1.23" t) list("U1.25" "NODE_JS_1" t) list("U1.26" "NODE_JS_2" t) list("U1.27" "NODE_JS_3" t) list("U1.28" "NODE_JS_4" t) list("U1.24" "C13.1" t) list("U1.23" "C13.2" t) list("C13.2" "U1.35" t) list("U1.20" "R29.1" t) list("U1.18" "LEFT07_VBUS18_VIA" t) list("U1.19" "LEFT_SOURCE_19_VIA" t) list("U1.14" "R23.1" t) list("R23.2" "J6.5" t) list("U1.15" "R21.1" t) list("R21.2" "J6.2" t) list("U1.10" "C24.1" t) list("C24.1" "R32.2" t) list("R32.1" "J10.1" t) list("R25.1" "U1.24" t) list("U1.37" "J9.4" t) list("U1.38" "J13.4" t) list("U1.39" "J9.6" t) list("U1.40" "J13.5" t) list("U1.41" "J13.6" t) list("U1.42" "J5.2" t) list("U1.43" "J5.3" t) list("U1.44" "J8.2" t) list("U1.45" "J13.7" t) list("U1.46" "J13.8" t) list("U1.42" "R19.2" t) list("U1.43" "R20.2" t) list("R28.2" "U1.23" t) list("U1.48" "C15.1" t) list("U1.47" "C15.2" t) list("C15.1" "C16.1" t) list("C15.2" "C16.2" t) list("U1.37" "NODE_JS_5" t) list("U1.38" "NODE_JS_6" t) list("U1.39" "NODE_JS_7" t) list("U1.40" "NODE_JS_8" t) list("U1.41" "NODE_JS_9" t) list("U1.42" "NODE_JS_10" t) list("U1.43" "NODE_JS_11" t) list("U1.44" "NODE_JS_12" t) list("U1.45" "NODE_JS_13" t) list("U1.46" "NODE_JS_14" t) list("RIGHT_RETURN_RIGHT_SDA_FAR_VIA" "U1.23" t) list("RIGHT_RETURN_RIGHT_PA15_FAR_VIA" "U1.23" t) list("RIGHT_RETURN_RIGHT_PB4_FAR_VIA" "U1.23" t) list("RIGHT_RETURN_RIGHT_PB5_MID_VIA" "U1.23" t) list("RIGHT_RETURN_RIGHT_PB5_FAR_VIA" "U1.23" t) list("RIGHT_RETURN_RIGHT_PB8_MID_VIA" "U1.23" t) list("RIGHT_RETURN_RIGHT_PB8_FAR_VIA" "U1.23" t) list("RIGHT_RETURN_RIGHT_SWO_FAR_VIA" "U1.23" t) list("RIGHT_SWCLK_WEST_RETURN" "U1.23" t) list("RIGHT_SWCLK_EAST_RETURN" "U1.23" t) list("RIGHT_SWCLK_MID_RETURN" "U1.23" t) list("R19.2" "J5.2" t) list("R20.2" "J5.3" t) list("R30.2" "J8.1" t) list("R12.2" "R14.2" t) list("U1.34" "J9.3" t) list("U1.31" "R17.1" t) list("U1.30" "R16.1" t) list("U1.29" "R10.2" t) list("U1.35" "ROOT_SWDIO_RETURN_COMMON" t) list("GPIO_NORTH_COMMON_RETURN" "U1.23" t) list("SOUTH_RETURN_WEST" "U1.23" t) list("SOUTH_RETURN_MID" "U1.23" t) list("SOUTH_RETURN_EAST" "U1.23" t) list("RIGHT_PC14_RETURN" "U1.23" t) list("HSE_SINGLE_ANCHOR_REWORK" "U1.23" t) list("RIGHT_C15_COMMON_GND" "U1.23" t) list("RIGHT_R28_GND_RETURN" "U1.23" t) list("ROOT_SWDIO_RETURN_COMMON" "U1.23" t) list("C10.1" "J2.A4_B9" t) list("C10.1" "J2.B4_A9" t) list("C10.1" "R7.1" t) list("C10.1" "U4.5" t) list("J6.2" "R21.2" t) list("R13.1" "R6.1" t) list("R13.1" "U1.32" t) list("C4.2" "L1.1" t) list("C4.2" "U2.2" t) list("J2.A6" "J2.B6" t) list("J2.A6" "R11.2" t) list("J2.A6" "R5.2" t) list("J2.A6" "U4.1" t) list("J2.A6" "U4.6" t) list("Q2.1" "R10.2" t) list("R14.2" "U5.1" t) list("J3.2" "R15.2" t) list("J3.2" "U5.6" t) list("J2.B5" "R4.1" t) list("J3.1" "R15.1" t) list("J3.1" "U5.7" t) list("R23.1" "R25.2" t) list("R23.1" "U1.14" t) list("R31.1" "U1.6" t) list("J2.A5" "R3.1" t) list("R12.1" "R5.1" t) list("R12.1" "U1.33" t) list("D1.2" "F1.2" t) list("C1.2" "C10.2" t) list("C1.2" "C11.2" t) list("C1.2" "C12.2" t) list("C1.2" "C13.2" t) list("C1.2" "C14.2" t) list("C1.2" "C15.2" t) list("C1.2" "C16.2" t) list("C1.2" "C17.2" t) list("C1.2" "C18.2" t) list("C1.2" "C19.2" t) list("C1.2" "C2.2" t) list("C1.2" "C20.2" t) list("C1.2" "C21.2" t) list("C1.2" "C22.2" t) list("C1.2" "C23.2" t) list("C1.2" "C24.2" t) list("C1.2" "C3.2" t) list("C1.2" "C5.2" t) list("C1.2" "C6.2" t) list("C1.2" "C8.2" t) list("C1.2" "C9.2" t) list("C1.2" "J1.2" t) list("C1.2" "J10.2" t) list("C1.2" "J11.2" t) list("C1.2" "J12.2" t) list("C1.2" "J13.2" t) list("C1.2" "J2.SH1" t) list("C1.2" "J2.SH2" t) list("C1.2" "J2.SH3" t) list("C1.2" "J2.SH4" t) list("C1.2" "J3.3" t) list("C1.2" "J4.4" t) list("C1.2" "J5.4" t) list("C1.2" "J6.6" t) list("C1.2" "J7.2" t) list("C1.2" "J9.2" t) list("C1.2" "R2.2" t) list("C1.2" "R28.2" t) list("C1.2" "R3.2" t) list("C1.2" "R4.2" t) list("C1.2" "U1.23" t) list("C1.2" "U1.35" t) list("C1.2" "U1.47" t) list("C1.2" "U1.8" t) list("C1.2" "U2.1" t) list("C1.2" "U3.2" t) list("C1.2" "U4.2" t) list("C1.2" "U5.2" t) list("C1.2" "Y1.2" t) list("C1.2" "Y1.4" t) list("C24.1" "U1.10" t) list("J4.3" "R18.1" t) list("C4.1" "U2.6" t) list("C11.1" "C12.1" t) list("C11.1" "C13.1" t) list("C11.1" "C14.1" t) list("C11.1" "C15.1" t) list("C11.1" "C16.1" t) list("C11.1" "C17.1" t) list("C11.1" "C9.1" t) list("C11.1" "J11.1" t) list("C11.1" "J12.1" t) list("C11.1" "J13.1" t) list("C11.1" "J4.1" t) list("C11.1" "J5.1" t) list("C11.1" "J6.1" t) list("C11.1" "J9.1" t) list("C11.1" "Q2.2" t) list("C11.1" "R10.1" t) list("C11.1" "R14.1" t) list("C11.1" "R18.2" t) list("C11.1" "R19.1" t) list("C11.1" "R20.1" t) list("C11.1" "R25.1" t) list("C11.1" "R26.1" t) list("C11.1" "R27.1" t) list("C11.1" "R30.1" t) list("C11.1" "R9.1" t) list("C11.1" "U1.1" t) list("C11.1" "U1.24" t) list("C11.1" "U1.36" t) list("C11.1" "U1.48" t) list("C11.1" "U3.5" t) list("C11.1" "U5.3" t) list("Q2.3" "R11.1" t) list("R24.1" "U1.16" t) list("C18.1" "C19.1" t) list("C18.1" "C20.1" t) list("C18.1" "R26.2" t) list("C18.1" "U1.9" t) list("Q1.3" "R9.2" t) list("F1.1" "J1.1" t) list("J6.5" "R23.2" t) list("C5.1" "C6.1" t) list("C5.1" "C7.1" t) list("C5.1" "C8.1" t) list("C5.1" "L1.2" t) list("C5.1" "R1.1" t) list("C5.1" "U3.1" t) list("C5.1" "U3.3" t) list("J6.3" "R22.2" t) list("J6.4" "R24.2" t) list("C7.2" "R1.2" t) list("C7.2" "R2.1" t) list("C7.2" "U2.4" t) list("J10.1" "R32.1" t) list("R21.1" "U1.15" t) list("R22.1" "U1.17" t) list("C23.1" "R31.2" t) list("C23.1" "Y1.3" t) list("J2.A7" "J2.B7" t) list("J2.A7" "R6.2" t) list("J2.A7" "U4.3" t) list("J2.A7" "U4.4" t) list("Q1.1" "R7.2" t) list("Q1.1" "R8.1" t) list("C22.1" "U1.5" t) list("C22.1" "Y1.1" t) list("C1.1" "C2.1" t) list("C1.1" "C3.1" t) list("C1.1" "D1.1" t) list("C1.1" "U2.3" t) list("C21.1" "U1.7" t) list("J12.1" "C9.1" t) list("R25.1" "C9.1" t) list("U1.21" "B016_NODE_175" t) list("U1.4" "J11.5" t) list("U1.1" "C17.1" t) list("R27.2" "C21.1" t) list("J7.1" "C21.1" t) list("J9.5" "C21.1" t) list("U1.18" "Q1.3" t) list("R16.2" "J4.2" t) list("R17.2" "R18.1" t) list("U1.35" "REM19_RETURN_NRST" t) list("U1.35" "REM19_RETURN_UART_TX" t) list("U1.35" "REM19_RETURN_VBUS_PRESENT_N" t) list("J2.A1_B12" "J2.SH1" t) list("J2.B1_A12" "J2.SH2" t) list("J2.A1_B12" "C10.2" t) list("J2.B1_A12" "C10.2" t) list("U5.4" "R13.2" t) list("U1.35" "J2.SH3" t) list("U1.35" "CAN2L_PHY_RETURN" t) list("U1.35" "CAN2L_REFERENCE_CROSS_LEFT" t) list("U1.35" "CAN2L_REFERENCE_CROSS_RIGHT" t) list("REM19_RETURN_NRST" "U1.23" t) list("REM19_RETURN_UART_TX" "U1.23" t) list("REM19_RETURN_VBUS_PRESENT_N" "U1.23" t) list("CAN2L_PHY_RETURN" "U1.23" t) list("CAN2L_REFERENCE_CROSS_LEFT" "U1.23" t) list("CAN2L_REFERENCE_CROSS_RIGHT" "U1.23" t) list("J9.6" "U1.39" t) list("R29.1" "U1.20" t) list("J8.1" "R30.2" t) list("J13.8" "U1.46" t) list("J8.2" "R28.1" t) list("J8.2" "U1.44" t) list("J13.6" "U1.41" t) list("Q2.1" "U1.29" t) list("R12.2" "U5.1" t) list("J13.4" "U1.38" t) list("J13.5" "U1.40" t) list("R25.2" "R23.1" t) list("R25.2" "U1.14" t) list("J5.2" "R19.2" t) list("J5.2" "U1.42" t) list("C19.1" "C18.1" t) list("C19.1" "C20.1" t) list("C19.1" "R26.2" t) list("C19.1" "U1.9" t) list("J9.3" "U1.34" t) list("J13.7" "U1.45" t) list("R16.1" "U1.30" t) list("J5.3" "R20.2" t) list("J5.3" "U1.43" t) list("J2.B7" "J2.A7" t) list("J2.B7" "R6.2" t) list("J2.B7" "U4.3" t) list("J2.B7" "U4.4" t) list("J9.4" "U1.37" t) list("R17.1" "U1.31" t) list("U1.25" "RETAINED_SOUTH_REAL_SOURCE_0" t) list("U1.26" "RETAINED_SOUTH_REAL_SOURCE_1" t) list("U1.27" "RETAINED_SOUTH_REAL_SOURCE_2" t) list("U1.28" "RETAINED_SOUTH_REAL_SOURCE_3" t) list("J2.SH2" "J2.SH4" t) list("J2.B1_A12" "C1.2" t) list("R13.2" "U5.4" t) list("C1.2" "J2.A1_B12" t) list("C1.2" "J2.B1_A12" t) list("J4.3" "R17.2" t) list("Q1.3" "U1.18" t) list("J4.2" "R16.2" t) list("C21.1" "J7.1" t) list("C21.1" "J9.5" t) list("C21.1" "R27.2" t) list("U1.2" "J11.3" t) list("U1.3" "J11.4" t) list("U1.11" "J11.6" t) list("U1.12" "J11.7" t) list("U1.13" "J11.8" t) list("C1.2" "N50_2L_RETURN_1" t) list("C1.2" "N50_2L_RETURN_2" t) list("C1.2" "N50_2L_RETURN_3" t) list("C1.2" "N50_2L_RETURN_4" t) list("U1.2" "NORTH_KEEP_EXISTING_0" t) list("U1.4" "NORTH_KEEP_EXISTING_1" t) list("U1.11" "NORTH_KEEP_EXISTING_2" t) list("U1.12" "NORTH_KEEP_EXISTING_3" t) list("U1.13" "NORTH_KEEP_EXISTING_4" t) list("C1.2" "NORTH_KEEP_EXISTING_5" t) list("U1.3" "N50_2L_N49_PC14_VIA" t) list("J2.SH4" "C1.2" t) list("J2.SH3" "C1.2" t) list("J2.SH2" "C1.2" t) list("J2.SH1" "C1.2" t) list("J2.A1_B12" "C1.2" t) list("J3.3" "C1.2" t) list("J4.4" "C1.2" t) list("J5.4" "C1.2" t) list("J6.6" "C1.2" t) list("J9.2" "C1.2" t) list("J11.2" "C1.2" t) list("J12.2" "C1.2" t) list("J13.2" "C1.2" t) list("C13.2" "C1.2" t) list("C14.2" "C1.2" t) list("C15.2" "C1.2" t) list("C17.2" "C1.2" t) list("C18.2" "C1.2" t) list("C19.2" "C1.2" t) list("C21.2" "C1.2" t) list("C22.2" "C1.2" t) list("C23.2" "C1.2" t) list("C24.2" "C1.2" t) list("R28.2" "C1.2" t) list("R29.2" "C1.2" t) list("C3.2" "C1.2" t) list("R2.2" "C1.2" t) list("C10.2" "C1.2" t) list("R3.2" "C1.2" t) list("R4.2" "C1.2" t) list("R8.2" "C1.2" t) list("C11.2" "C1.2" t) list("C12.2" "C1.2" t) list("U1.47" "C1.2" t) list("U1.35" "C1.2" t) list("U1.23" "C1.2" t) list("U1.8" "C1.2" t) list("C16.2" "C1.2" t) list("C20.2" "C1.2" t) list("C8.2" "C1.2" t) list("C9.2" "C1.2" t) list("Y1.4" "C1.2" t) list("Y1.2" "C1.2" t) list("J7.2" "C1.2" t) list("J10.2" "C1.2" t) list("J1.2" "C1.2" t) list("C1.2" "C1.2" t) list("C2.2" "C1.2" t) list("C5.2" "C1.2" t) list("C6.2" "C1.2" t) list("U2.1" "C1.2" t) list("U4.2" "C1.2" t) list("U3.2" "C1.2" t) list("Q1.2" "C1.2" t) list("U5.2" "C1.2" t) list("B018_ALL_REAL_GND_VIA_0" "C1.2" t) list("B018_ALL_REAL_GND_VIA_1" "C1.2" t) list("B018_ALL_REAL_GND_VIA_2" "C1.2" t) list("B018_ALL_REAL_GND_VIA_3" "C1.2" t) list("B018_ALL_REAL_GND_VIA_4" "C1.2" t) list("B018_ALL_REAL_GND_VIA_5" "C1.2" t) list("B018_ALL_REAL_GND_VIA_6" "C1.2" t) list("B018_ALL_REAL_GND_VIA_7" "C1.2" t) list("B018_ALL_REAL_GND_VIA_8" "C1.2" t) list("B018_ALL_REAL_GND_VIA_9" "C1.2" t) list("B018_ALL_REAL_GND_VIA_10" "C1.2" t) list("B018_ALL_REAL_GND_VIA_11" "C1.2" t) list("B018_ALL_REAL_GND_VIA_12" "C1.2" t) list("B018_ALL_REAL_GND_VIA_13" "C1.2" t) list("B018_ALL_REAL_GND_VIA_14" "C1.2" t) list("B018_ALL_REAL_GND_VIA_15" "C1.2" t) list("B018_ALL_REAL_GND_VIA_16" "C1.2" t) list("B018_ALL_REAL_GND_VIA_17" "C1.2" t) list("B018_ALL_REAL_GND_VIA_18" "C1.2" t) list("B018_ALL_REAL_GND_VIA_19" "C1.2" t) list("B018_ALL_REAL_GND_VIA_20" "C1.2" t) list("B018_ALL_REAL_GND_VIA_21" "C1.2" t) list("B018_ALL_REAL_GND_VIA_22" "C1.2" t) list("B018_ALL_REAL_GND_VIA_23" "C1.2" t) list("B018_ALL_REAL_GND_VIA_24" "C1.2" t) list("B018_ALL_REAL_GND_VIA_25" "C1.2" t) list("B018_ALL_REAL_GND_VIA_26" "C1.2" t) list("B018_ALL_REAL_GND_VIA_27" "C1.2" t) list("B018_ALL_REAL_GND_VIA_28" "C1.2" t) list("B018_ALL_REAL_GND_VIA_29" "C1.2" t) list("B018_ALL_REAL_GND_VIA_30" "C1.2" t) list("B018_ALL_REAL_GND_VIA_31" "C1.2" t) list("B018_ALL_REAL_GND_VIA_32" "C1.2" t) list("B018_ALL_REAL_GND_VIA_33" "C1.2" t) list("B018_ALL_REAL_GND_VIA_34" "C1.2" t) list("B018_ALL_REAL_GND_VIA_35" "C1.2" t) list("B018_ALL_REAL_GND_VIA_36" "C1.2" t) list("B018_ALL_REAL_GND_VIA_37" "C1.2" t) list("B018_ALL_REAL_GND_VIA_38" "C1.2" t) list("B018_ALL_REAL_GND_VIA_39" "C1.2" t) list("B018_ALL_REAL_GND_VIA_40" "C1.2" t) list("B018_ALL_REAL_GND_VIA_41" "C1.2" t) list("B018_ALL_REAL_GND_VIA_42" "C1.2" t) list("B018_ALL_REAL_GND_VIA_43" "C1.2" t) list("B018_ALL_REAL_GND_VIA_44" "C1.2" t) list("B018_ALL_REAL_GND_VIA_45" "C1.2" t) list("B018_ALL_REAL_GND_VIA_46" "C1.2" t) list("B018_ALL_REAL_GND_VIA_47" "C1.2" t) list("B018_ALL_REAL_GND_VIA_48" "C1.2" t) list("B018_ALL_REAL_GND_VIA_49" "C1.2" t) list("B018_ALL_REAL_GND_VIA_50" "C1.2" t) list("B018_ALL_REAL_GND_VIA_51" "C1.2" t) list("B018_ALL_REAL_GND_VIA_52" "C1.2" t) list("B018_ALL_REAL_GND_VIA_53" "C1.2" t) list("B018_ALL_REAL_GND_VIA_54" "C1.2" t) list("B018_ALL_REAL_GND_VIA_55" "C1.2" t) list("B018_ALL_REAL_GND_VIA_56" "C1.2" t) list("B018_ALL_REAL_GND_VIA_57" "C1.2" t) list("B018_ALL_REAL_GND_VIA_58" "C1.2" t) list("B018_ALL_REAL_GND_VIA_59" "C1.2" t) list("B018_ALL_REAL_GND_VIA_60" "C1.2" t) list("B018_ALL_REAL_GND_VIA_61" "C1.2" t) list("B018_ALL_REAL_GND_VIA_62" "C1.2" t) list("B018_ALL_REAL_GND_VIA_63" "C1.2" t) list("B018_ALL_REAL_GND_VIA_64" "C1.2" t) list("B018_ALL_REAL_GND_VIA_65" "C1.2" t) list("B018_ALL_REAL_GND_VIA_66" "C1.2" t) list("B018_ALL_REAL_GND_VIA_67" "C1.2" t) list("B018_ALL_REAL_GND_VIA_68" "C1.2" t) list("B018_ALL_REAL_GND_VIA_69" "C1.2" t) list("B018_ALL_REAL_GND_VIA_70" "C1.2" t) list("B018_ALL_REAL_GND_VIA_71" "C1.2" t) list("B018_ALL_REAL_GND_VIA_72" "C1.2" t) list("B018_ALL_REAL_GND_VIA_73" "C1.2" t) list("B018_ALL_REAL_GND_VIA_74" "C1.2" t) list("B018_ALL_REAL_GND_VIA_75" "C1.2" t) list("B018_ALL_REAL_GND_VIA_76" "C1.2" t) list("B018_ALL_REAL_GND_VIA_77" "C1.2" t) list("B018_ALL_REAL_GND_VIA_78" "C1.2" t) list("B018_ALL_REAL_GND_VIA_79" "C1.2" t) list("B018_ALL_REAL_GND_VIA_80" "C1.2" t) list("B018_ALL_REAL_GND_VIA_81" "C1.2" t) list("B018_ALL_REAL_GND_VIA_82" "C1.2" t) list("B018_ALL_REAL_GND_VIA_83" "C1.2" t)))
  t))
