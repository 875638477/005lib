; Root-authorized intermediate only: whole-board interactive checks, all modes unchanged; batch-t and final fullfresh remain pending.
procedure(hiFinalize(f out board lib proofs)
 let((count drcResult)
  unless(equal(axlShapeDynamicUpdate(nil t) 0) error("Actual shape update failed\n"))
  axlDBRefreshId(nil)
  foreach(p proofs hiProof(f car(p) cadr(p) caddr(p)))
  fprintf(f "HI_INTERMEDIATE_INTERACTIVE_DRC_REQUEST_BEGIN time=%L g_mode=nil online=%L physicalModes=%L spacingModes=%L electricalModes=%L\n" getCurrentTime() axlDBControl('drcEnable) axlCNSPhysicalModeGet('all) axlCNSSpacingModeGet('all) axlCNSEcsetModeGet('all)) drain(f)
  drcResult=axlDRCUpdate(nil)
  fprintf(f "HI_INTERMEDIATE_INTERACTIVE_DRC_REQUEST_RETURN time=%L result=%L online=%L storedDRCs=%d\n" getCurrentTime() drcResult axlDBControl('drcEnable) length(axlDBGetDesign()->drcs)) drain(f)
  unless(numberp(drcResult) error("Interactive whole-board DRC returned nil/non-numeric; no pass may be asserted\n"))
  f29DumpDRC(f "HI_BATCH_INTERACTIVE_ONLY_FINAL_BATCH_T_PENDING")
  count=length(axlDBGetDesign()->drcs)
  unless(axlSaveDesign(?design board ?noMru t ?noConfirm t) error("Cannot save HI candidate checkpoint\n"))
  fprintf(f "HI_BATCH_COMPLETED drcCount=%d status=%s board=%L\n" count if(count==0 then "INTERMEDIATE_INTERACTIVE_ONLY_BATCH_T_PENDING" else "FAILED_INTERACTIVE_DRC_BATCH_T_PENDING") board)
  close(f)
  gSnapshot(out lib)
  hiNetworkInventory(out)
  t))
