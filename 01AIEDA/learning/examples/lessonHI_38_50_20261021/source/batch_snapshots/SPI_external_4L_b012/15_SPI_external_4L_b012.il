procedure(hiBatchProgram()
 let((f)
  f=outfile("D:/001DIY/005lib/01AIEDA/learning/examples/lessonHI_38_50_20261021/logs/SPI_external_4L_b012/hi_batch_execution.txt")
  fprintf(f "HI_BATCH_DRC_BEFORE=%L\n" axlDBControl('drcEnable))
  unwindProtect(
   progn(
    axlDBControl('drcEnable nil)
    fprintf(f "HI_ASSEMBLY_ONLINE_DRC_TEMPORARILY_DISABLED=%L\n" axlDBControl('drcEnable))
    hiRegistry=nil
    hiNodeDefinitions=list(list("HI_4L_SPI_SCK_1_V1" "SPI_SCK" "TOP" list(31.0 29.95) "via") list("HI_4L_SPI_SCK_1_R1" "SPI_SCK" "TOP" list(32.0252 31.0) "point") list("HI_4L_SPI_SCK_1_R2" "SPI_SCK" "BOTTOM" list(31.0 29.95) "point") list("HI_4L_SPI_MISO_1_V1" "SPI_MISO" "TOP" list(31.65 28.2) "via") list("HI_4L_SPI_MISO_1_V2" "SPI_MISO" "TOP" list(15.7 29.3) "via") list("HI_4L_SPI_MISO_1_R1" "SPI_MISO" "TOP" list(32.0252 29.0) "point") list("HI_4L_SPI_MISO_1_R2" "SPI_MISO" "BOTTOM" list(31.65 28.2) "point") list("HI_4L_SPI_MISO_1_R3" "SPI_MISO" "TOP" list(15.7 29.3) "point") list("HI_4L_SPI_MOSI_1_V1" "SPI_MOSI" "TOP" list(32.7 26.25) "via") list("HI_4L_SPI_MOSI_1_V2" "SPI_MOSI" "TOP" list(12.65 28.65) "via") list("HI_4L_SPI_MOSI_1_R1" "SPI_MOSI" "TOP" list(32.0252 27.0) "point") list("HI_4L_SPI_MOSI_1_R2" "SPI_MOSI" "BOTTOM" list(32.7 26.25) "point") list("HI_4L_SPI_MOSI_1_R3" "SPI_MOSI" "TOP" list(12.65 28.65) "point") list("HI_4L_SPI_NSS_1_V1" "SPI_NSS" "TOP" list(29.8 32.3) "via") list("HI_4L_SPI_NSS_1_R1" "SPI_NSS" "TOP" list(31.2236 33.02) "point") list("HI_4L_SPI_NSS_1_R2" "SPI_NSS" "BOTTOM" list(29.8 32.3) "point") list("SPI4_RETURN_1" "GND" "TOP" list(30.95 29.0) "via") list("SPI4_RETURN_2" "GND" "TOP" list(15.1 28.55) "via") list("SPI4_RETURN_3" "GND" "TOP" list(12.2 27.8) "via") list("SPI4_RETURN_4" "GND" "TOP" list(29.2 33.05) "via"))
    hiVia(f "HI_4L_SPI_SCK_1_V1" "SPI_SCK" list(31.0 29.95) "L28_VIA030_C060")
    hiRoute(f "HI_4L_SPI_SCK_1_R1" "SPI_SCK" "TOP" list(list(32.0252 31.0) list(32.05 31.0) list(31.0 29.95)) list(0.2 0.2))
    hiRoute(f "HI_4L_SPI_SCK_1_R2" "SPI_SCK" "BOTTOM" list(list(31.0 29.95) list(8.4 29.95) list(7.0 28.55) list(7.0 28.54)) list(0.2 0.2 0.2))
    hiVia(f "HI_4L_SPI_MISO_1_V1" "SPI_MISO" list(31.65 28.2) "L28_VIA030_C060")
    hiVia(f "HI_4L_SPI_MISO_1_V2" "SPI_MISO" list(15.7 29.3) "L28_VIA030_C060")
    hiRoute(f "HI_4L_SPI_MISO_1_R1" "SPI_MISO" "TOP" list(list(32.0252 29.0) list(32.05 29.0) list(31.65 28.6) list(31.65 28.2)) list(0.2 0.2 0.2))
    hiRoute(f "HI_4L_SPI_MISO_1_R2" "SPI_MISO" "BOTTOM" list(list(31.65 28.2) list(24.9 28.2) list(23.8 29.3) list(15.7 29.3)) list(0.2 0.2 0.2))
    hiRoute(f "HI_4L_SPI_MISO_1_R3" "SPI_MISO" "TOP" list(list(15.7 29.3) list(11.3 29.3) list(7.0 33.6) list(7.0 33.62)) list(0.2 0.2 0.2))
    hiVia(f "HI_4L_SPI_MOSI_1_V1" "SPI_MOSI" list(32.7 26.25) "L28_VIA030_C060")
    hiVia(f "HI_4L_SPI_MOSI_1_V2" "SPI_MOSI" list(12.65 28.65) "L28_VIA030_C060")
    hiRoute(f "HI_4L_SPI_MOSI_1_R1" "SPI_MOSI" "TOP" list(list(32.0252 27.0) list(32.05 27.0) list(32.05 26.9) list(32.7 26.25)) list(0.2 0.2 0.2))
    hiRoute(f "HI_4L_SPI_MOSI_1_R2" "SPI_MOSI" "BOTTOM" list(list(32.7 26.25) list(15.05 26.25) list(12.65 28.65)) list(0.2 0.2))
    hiRoute(f "HI_4L_SPI_MOSI_1_R3" "SPI_MOSI" "TOP" list(list(12.65 28.65) list(9.45 28.65) list(7.0 31.1) list(7.0 31.08)) list(0.2 0.2 0.2))
    hiVia(f "HI_4L_SPI_NSS_1_V1" "SPI_NSS" list(29.8 32.3) "L28_VIA030_C060")
    hiRoute(f "HI_4L_SPI_NSS_1_R1" "SPI_NSS" "TOP" list(list(31.2236 33.02) list(31.2 33.0) list(30.5 33.0) list(29.8 32.3)) list(0.2 0.2 0.2))
    hiRoute(f "HI_4L_SPI_NSS_1_R2" "SPI_NSS" "BOTTOM" list(list(29.8 32.3) list(29.15 31.65) list(29.15 31.55) list(29.1 31.5) list(11.65 31.5) list(7.0 36.15) list(7.0 36.16)) list(0.2 0.2 0.2 0.2 0.2 0.2))
    hiVia(f "SPI4_RETURN_1" "GND" list(30.95 29.0) "L28_VIA030_C060")
    hiVia(f "SPI4_RETURN_2" "GND" list(15.1 28.55) "L28_VIA030_C060")
    hiVia(f "SPI4_RETURN_3" "GND" list(12.2 27.8) "L28_VIA030_C060")
    hiVia(f "SPI4_RETURN_4" "GND" list(29.2 33.05) "L28_VIA030_C060")
    hiHSEIsolationChallengeGraph("D:/001DIY/005lib/01AIEDA/learning/examples/lessonHI_38_50_20261021/logs/SPI_external_4L_b012" list(45.45 28.85) "L2" list(list(42.2 39.8) list(44.2 39.8) list(47.8 33.5)))
    t)
   progn(
    axlDBControl('drcEnable t)
    fprintf(f "HI_UNWIND_DRC_RESTORED=%L\n" axlDBControl('drcEnable))))
  unless(axlDBControl('drcEnable) error("Final DRC must be enabled\n"))
  hiFinalize(f "D:/001DIY/005lib/01AIEDA/learning/examples/lessonHI_38_50_20261021/logs/SPI_external_4L_b012" "D:/001DIY/005lib/01AIEDA/learning/examples/lessonHI_38_50_20261021/native/HI_4L_SPI_external_4L_b012.brd" "D:/001DIY/005lib/01AIEDA/learning/examples/lessonHI_38_50_20261021/library" list(list("R21.2" "J6.2" t) list("R22.2" "J6.3" t) list("R24.2" "J6.4" t) list("R23.2" "J6.5" t) list("SPI4_RETURN_1" "U1.23" t) list("SPI4_RETURN_2" "U1.23" t) list("SPI4_RETURN_3" "U1.23" t) list("SPI4_RETURN_4" "U1.23" t)))
  t))
