procedure(hiBindExistingShape(f id net layer)
 let((boundaries b)
  boundaries=nil
  foreach(s axlDBGetShapes(strcat("ETCH/" layer))
   when(s->net && equal(s->net->name net) && s->shapeBoundary
    b=s->shapeBoundary
    unless(member(b boundaries) boundaries=cons(b boundaries))))
  unless(length(boundaries)==1 error("Expected exactly one existing dynamic application shape %s %s found=%L\n" net layer boundaries))
  b=car(boundaries)
  fprintf(f "HI_BIND_EXISTING_SHAPE id=%L net=%L layer=%L boundary=%L\n" id net layer b->??)
  hiReg(id "shape" b)
  b))
procedure(hiVoid(f shapeId points)
 let((row shape opened void ret)
  row=assoc(shapeId hiRegistry)
  unless(row error("Void requires known shape id %s\n" shapeId))
  shape=caddr(row)
  opened=axlDBOpenShape(shape)
  unless(opened error("Cannot open shape for permanent void\n"))
  void=axlDBCreateVoid(opened hiClosedPath(points))
  unless(void error("Cannot create permanent void\n"))
  ret=axlDBCreateCloseShape(opened t)
  unless(ret error("Cannot close shape after permanent void\n"))
  hiRegistry=remove(row hiRegistry)
  hiReg(shapeId "shape" car(ret))
  fprintf(f "HI_PERMANENT_VOID shapeId=%L polygon=%L void=%L actual=%L\n" shapeId points void->?? car(ret)->??)
  t))
procedure(hiHSEIsolationChallenge(out anchorXY localLayer guardPoints)
 let((f mark via beforeCount graph quietShape guard)
  f=outfile(strcat(out "/hi_hse_isolation_challenge.txt"))
  axlShapeDynamicUpdate(nil t) axlDBRefreshId(nil)
  axlDRCUpdate(t) axlDBRefreshId(nil)
  beforeCount=length(axlDBGetDesign()->drcs)
  hiProof(f "C22.2" "C23.2" t)
  hiProof(f "C22.2" "U1.47" t)
  hiProof(f "C22.2" "Y1.2" t)
  mark=axlDBTransactionStart()
  unless(mark error("Cannot start HSE isolation negative-test transaction\n"))
  via=hiResolvePoint("GND" "TOP" anchorXY "via")
  fprintf(f "HSE_NEGATIVE_DELETE_ONLY_ANCHOR=%L\n" via->??)
  unless(axlDeleteObject(via) error("Cannot delete single HSE bridge via\n"))
  axlShapeDynamicUpdate(nil t) axlDBRefreshId(nil)
  hiProof(f "C22.2" "C23.2" t)
  graph=gConnectedObjects(gPin("C22" "2"))
  quietShape=setof(s graph equal(s->objType "shape") && equal(s->layer strcat("ETCH/" localLayer)) && s->fill)
  unless(quietShape error("Local island disconnected in anchor-negative test\n"))
  foreach(guardXY guardPoints
   guard=hiResolvePoint("GND" "TOP" guardXY "point")
   fprintf(f "NEGATIVE_LOCAL_REFERENCE count=%d guardXY=%L guardReached=%L\n" length(quietShape) guardXY if(member(guard graph) then t else nil))
   unless(member(guard graph) error("Quiet guard disconnected in anchor-negative test\n")))
  hiProof(f "C22.2" "U1.47" nil)
  hiProof(f "C22.2" "Y1.2" nil)
  hiProof(f "C15.2" "U1.47" t)
  hiProof(f "Y1.2" "Y1.4" t)
  hiProof(f "Y1.2" "U1.47" t)
  fprintf(f "HSE_NEGATIVE_ACTUAL_GND_NET_UNCONNECTED=%L\n" axlDBFindByName('net "GND")->unconnected)
  unless(axlDBTransactionRollback(mark) error("Cannot rollback HSE anchor deletion\n"))
  axlShapeDynamicUpdate(nil t) axlDBRefreshId(nil)
  hiProof(f "C22.2" "C23.2" t)
  hiProof(f "C22.2" "U1.47" t)
  hiProof(f "C22.2" "Y1.2" t)
  axlDRCUpdate(t) f29DumpDRC(f "HSE_ANCHOR_RESTORED")
  unless(length(axlDBGetDesign()->drcs)==beforeCount error("Restored HSE DRC count differs\n"))
  fprintf(f "HSE_ISOLATION_NEGATIVE_TEST_COMPLETE_NO_SAVE\n") close(f) t))

procedure(hiAssignNetClass(f name domain cset nets)
 let((nc net old prop)
  nc=axlNetClassCreate(name domain)
  unless(nc error("Cannot create scoped netclass %s\n" name))
  prop=if(equal(domain 'physical) then "PHYSICAL_CONSTRAINT_SET" else "SPACING_CONSTRAINT_SET")
  unless(axlDBAddProp(list(nc) list(list(prop cset))) error("Cannot assign scoped class CSet\n"))
  foreach(n nets
   net=axlDBFindByName('net n)
   unless(net error("Missing logical net while assigning class\n"))
   old=axlNetClassGet(net domain t)
   when(old unless(axlNetClassRemove(old net) error("Cannot remove old domain class member\n")))
   unless(axlNetClassAdd(nc net) error("Cannot add scoped class member\n"))
   fprintf(f "HI_CLASS_REASSIGN net=%L domain=%L old=%L new=%L baseCSet=%L directNetProperties=%L\n" n domain if(old then old->name else nil) name cset axlDBGetProperties(net)))
  axlCNSMapUpdate()
  t))

procedure(hiBindExistingStaticShape(f id net layer)
 let((shapes)
  shapes=setof(s axlDBGetShapes(strcat("ETCH/" layer)) s->net && equal(s->net->name net) && !s->shapeBoundary && !s->shapeIsBoundary && s->fill)
  unless(length(shapes)==1 error("Expected one actual static reference shape %s/%s found=%L\n" net layer shapes))
  fprintf(f "HI_BIND_STATIC_SHAPE id=%L layer=%L shape=%L\n" id layer car(shapes)->??)
  hiReg(id "shape" car(shapes))
  car(shapes)))
procedure(hiShapeBoundaryRead(out)
 let((f poly holes)
  f=outfile(strcat(out "/hi_dynamic_boundaries.tsv"))
  fprintf(f "layer\tnet\tbbox\tvertices\tpermanentVoids\tattributes\n")
  foreach(s axlDBGetShapes("BOUNDARY")
   poly=car(axlPolyFromDB(s)) holes=nil
   foreach(v s->voids
    foreach(p axlPolyFromDB(v) holes=append(holes list(p->vertices))))
   fprintf(f "%L\t%L\t%L\t%L\t%L\t%L\n" s->layer if(s->net then s->net->name else nil) s->bBox if(poly then poly->vertices else nil) holes s->??))
  fprintf(f "HI_DYNAMIC_BOUNDARY_READ_COMPLETE\n") close(f) t))

procedure(hiShape(f id net layer points dynamic voids)
 let((shape ret boundary geometry)
  geometry=if(equal(points "ROUTE_KEEPIN") then car(axlPolyFromDB(axlDBGetDesign()->keepinRoute)) else hiClosedPath(points))
  unless(geometry error("No valid shape outline geometry\n"))
  shape=axlDBCreateOpenShape(geometry t strcat("ETCH/" layer) net)
  unless(shape error("Cannot create actual open ETCH shape\n"))
  foreach(v voids
   unless(axlDBCreateVoid(shape hiClosedPath(v)) error("Cannot create permanent void before shape close\n")))
  ret=axlDBCreateCloseShape(shape t)
  unless(ret error("Cannot close actual ETCH shape with requested voids\n"))
  shape=car(ret)
  when(dynamic
   boundary=axlShapeChangeDynamicType(shape t t)
   unless(boundary error("Cannot convert reference shape to dynamic\n"))
   shape=boundary
   unless(equal(axlShapeDynamicUpdate(shape t) 0) error("Reference shape update failed\n")))
  fprintf(f "HI_SHAPE id=%L net=%L layer=%L dynamic=%L requestedVoidCount=%d object=%L\n" id net layer dynamic length(voids) shape->??)
  hiReg(id "shape" shape)
  shape))

procedure(hiCSetLayerValue(f domain name layer key value)
 let((ret actual)
  if(equal(domain 'physical) then
   ret=axlCNSSetPhysical(name layer key value)
   actual=axlCNSGetPhysical(name layer key)
  else
   ret=axlCNSSetSpacing(name layer key value)
   actual=axlCNSGetSpacing(name layer key))
  unless(ret error("Cannot set layer-specific CSet field\n"))
  fprintf(f "HI_CSET_LAYER_VALUE domain=%L cset=%L layer=%L key=%L requested=%L actual=%L\n" domain name layer key value actual)
  t))
procedure(hiRegion(f id layer polygon assignments)
 let((region shape tbl)
  region=axlRegionCreate(id)
  unless(region error("Cannot create region %s\n" id))
  shape=car(axlDBCreateShape(hiClosedPath(polygon) nil strcat("CONSTRAINT REGION/" layer)))
  unless(shape && axlRegionAdd(region shape) error("Cannot create actual region polygon\n"))
  foreach(a assignments
   tbl=axlCnsClassTableCreate(car(a) nth(3 a) region cadr(a) caddr(a))
   unless(tbl error("Cannot assign Region-Class or Region-Class-Class rule\n"))
   fprintf(f "HI_REGION_CLASS region=%L class1=%L class2=%L domain=%L cset=%L table=%L\n" id car(a) nth(3 a) cadr(a) caddr(a) tbl->??))
  fprintf(f "HI_REGION_GEOMETRY %L\n" shape->??)
  axlCNSMapUpdate()
  t))

procedure(hiDeleteSegment(f id net layer points width)
 let((matches seen obj old countBefore countAfter)
  matches=nil seen=nil
  foreach(obj axlExtractMap("C:/Program0/Cadence/SPB172/share/pcb/text/views/fgeo_bv.txt" nil)
   unless(member(obj seen)
    seen=cons(obj seen)
    when(equal(obj->objType "line") && obj->isEtch && obj->net && equal(obj->net->name net) && equal(obj->layer strcat("ETCH/" layer)) && abs(obj->width-width)<0.00001 &&
      (equal(obj->startEnd points) || equal(reverse(obj->startEnd) points))
     matches=cons(obj matches))))
  unless(length(matches)==1 error("Exact old cline segment not uniquely found for controlled ripup %s found=%L\n" id matches))
  old=car(matches)
  fprintf(f "HI_DELETE_EXACT_SEGMENT id=%L before=%L parentType=%L thermal=%L\n" id old->?? old->parent->objType old->thermal)
  when(old->thermal || (old->parent && old->parent->thermal) error("Refuse explicit manual-ripup operation on generated thermal relief (line or parent path)\n"))
  unless(axlDeleteObject(old) error("Cannot delete exact selected cline segment\n"))
  axlDBRefreshId(nil)
  fprintf(f "HI_DELETE_EXACT_SEGMENT_COMPLETE id=%L net=%L layer=%L points=%L width=%L\n" id net layer points width)
  t))
procedure(hiRouteRoles(out)
 let((f seen p g count thermalCount)
  f=outfile(strcat(out "/hi_route_roles.tsv"))
  fprintf(f "net\tlayer\tstartEnd\twidth\tisEtch\tthermal\tparentType\tparentAttributes\tgrandparentType\n")
  seen=nil count=0 thermalCount=0
  foreach(o axlExtractMap("C:/Program0/Cadence/SPB172/share/pcb/text/views/fgeo_bv.txt" nil)
   unless(member(o seen)
    seen=cons(o seen)
    when(equal(o->objType "line") && o->layer && rexMatchp("^ETCH/" o->layer)
     p=o->parent g=if(p then p->parent else nil)
     count=count+1
     when(o->thermal thermalCount=thermalCount+1)
     fprintf(f "%L\t%L\t%L\t%L\t%L\t%L\t%L\t%L\t%L\n" if(o->net then o->net->name else nil) o->layer o->startEnd o->width o->isEtch o->thermal if(p then p->objType else nil) if(p then p->?? else nil) if(g then g->objType else nil)))))
  close(f)
  f=outfile(strcat(out "/hi_route_roles_summary.txt"))
  fprintf(f "actualEtchLines=%d\nthermalReliefLines=%d\nHI_ROUTE_ROLES_COMPLETE\n" count thermalCount)
  close(f) t))

procedure(hiECSetCopy(f name copy values pairName)
 let((ec pair)
  ec=axlCNSEcsetCreate(name copy)
  unless(ec error("Cannot copy electrical CSet template\n"))
  foreach(v values
   unless(axlCNSEcsetValueSet(name car(v) cadr(v)) error("Cannot set scoped electrical CSet field\n"))
   fprintf(f "HI_ECSET_VALUE name=%L key=%L requested=%L actual=%L\n" name car(v) cadr(v) axlCNSEcsetValueGet(name car(v))))
  pair=car(setof(p axlDBGetDesign()->diffpair equal(p->name pairName)))
  unless(pair error("Differential pair target not found\n"))
  unless(axlDBAddProp(list(pair) list(list("ELECTRICAL_CONSTRAINT_SET" name))) error("Cannot assign pair-specific electrical CSet\n"))
  axlCNSMapUpdate()
  fprintf(f "HI_PAIR_ECSET_COPY pair=%L sourceTemplate=%L newCSet=%L properties=%L pairAttributes=%L\n" pairName copy name axlDBGetProperties(pair) pair->??)
  t))

procedure(hiUSBMaskRead(out)
 let((f objects via pad cls)
  f=outfile(strcat(out "/hi_usb_key_mask_apertures.tsv"))
  fprintf(f "role\tobject\tpadstack\txy\tqueryLayer\tfigure\tpadBBoxRelativePinXY\tpadAttributes\n")
  objects=list(list("U4_VBUS_PIN5" gPin("U4" "5") "PIN") list("C10_VBUS_PIN1" gPin("C10" "1") "PIN"))
  foreach(v axlExtractMap("C:/Program0/Cadence/SPB172/share/pcb/text/views/fgeo_bv.txt" nil)
   when(equal(v->objType "via") && equal(v->xy list(40.25 9.3)) && v->net && equal(v->net->name "USB_VBUS")
    unless(member(v mapcar('cadr objects)) objects=append(objects list(list("ESD_VBUS_LEFT_VIA" v "VIA CLASS"))))))
  foreach(row objects
   foreach(side list("TOP" "BOTTOM")
    cls=strcat(caddr(row) "/SOLDERMASK_" side)
    pad=axlDBGetPad(cadr(row) cls "REGULAR")
    fprintf(f "%L\t%L\t%L\t%L\t%L\t%L\t%L\t%L\n" car(row) cadr(row) cadr(row)->name cadr(row)->xy cls if(pad then pad->figureName else nil) if(pad then pad->bBox else nil) if(pad then pad->?? else nil))))
  fprintf(f "HI_USB_KEY_MASK_APERTURES_COMPLETE\n") close(f) t))

procedure(hiHSEIsolationChallengeGraph(out anchorXY localLayer guardPoints)
 let((f mark via beforeCount graph quietShape guard)
  f=outfile(strcat(out "/hi_hse_isolation_challenge.txt"))
  axlShapeDynamicUpdate(nil t) axlDBRefreshId(nil)
  beforeCount=length(axlDBGetDesign()->drcs)
  hiProof(f "C22.2" "C23.2" t)
  hiProof(f "C22.2" "U1.47" t)
  hiProof(f "C22.2" "Y1.2" t)
  mark=axlDBTransactionStart()
  unless(mark error("Cannot start HSE isolation negative-test transaction\n"))
  via=hiResolvePoint("GND" "TOP" anchorXY "via")
  fprintf(f "HSE_NEGATIVE_DELETE_ONLY_ANCHOR=%L\n" via->??)
  unless(axlDeleteObject(via) error("Cannot delete single HSE bridge via\n"))
  axlShapeDynamicUpdate(nil t) axlDBRefreshId(nil)
  hiProof(f "C22.2" "C23.2" t)
  graph=gConnectedObjects(gPin("C22" "2"))
  quietShape=setof(s graph equal(s->objType "shape") && equal(s->layer strcat("ETCH/" localLayer)) && s->fill)
  unless(quietShape error("Local island disconnected in anchor-negative test\n"))
  foreach(guardXY guardPoints
   guard=hiResolvePoint("GND" "TOP" guardXY "point")
   fprintf(f "NEGATIVE_LOCAL_REFERENCE count=%d guardXY=%L guardReached=%L\n" length(quietShape) guardXY if(member(guard graph) then t else nil))
   unless(member(guard graph) error("Quiet guard disconnected in anchor-negative test\n")))
  hiProof(f "C22.2" "U1.47" nil)
  hiProof(f "C22.2" "Y1.2" nil)
  hiProof(f "C15.2" "U1.47" t)
  hiProof(f "Y1.2" "Y1.4" t)
  hiProof(f "Y1.2" "U1.47" t)
  fprintf(f "HSE_NEGATIVE_ACTUAL_GND_NET_UNCONNECTED=%L\n" axlDBFindByName('net "GND")->unconnected)
  unless(axlDBTransactionRollback(mark) error("Cannot rollback HSE anchor deletion\n"))
  axlShapeDynamicUpdate(nil t) axlDBRefreshId(nil)
  hiProof(f "C22.2" "C23.2" t)
  hiProof(f "C22.2" "U1.47" t)
  hiProof(f "C22.2" "Y1.2" t)
  fprintf(f "HSE_ISOLATION_GRAPH_NEGATIVE_TEST_COMPLETE_FULL_DRC_REQUIRED\n") close(f) t))

procedure(hiRouteRoles(out)
 let((f seen p g count thermalCount parentThermal effectiveThermal)
  f=outfile(strcat(out "/hi_route_roles.tsv"))
  fprintf(f "net\tlayer\tstartEnd\twidth\tisEtch\tthermal\tlineThermal\tparentThermal\tparentType\tparentAttributes\tgrandparentType\n")
  seen=nil count=0 thermalCount=0
  foreach(o axlExtractMap("C:/Program0/Cadence/SPB172/share/pcb/text/views/fgeo_bv.txt" nil)
   unless(member(o seen)
    seen=cons(o seen)
    when(equal(o->objType "line") && o->layer && rexMatchp("^ETCH/" o->layer)
     p=o->parent g=if(p then p->parent else nil)
     parentThermal=if(p then p->thermal else nil)
     effectiveThermal=if(o->thermal || parentThermal then t else nil)
     count=count+1
     when(effectiveThermal thermalCount=thermalCount+1)
     fprintf(f "%L\t%L\t%L\t%L\t%L\t%L\t%L\t%L\t%L\t%L\t%L\n" if(o->net then o->net->name else nil) o->layer o->startEnd o->width o->isEtch effectiveThermal o->thermal parentThermal if(p then p->objType else nil) if(p then p->?? else nil) if(g then g->objType else nil)))))
  close(f)
  f=outfile(strcat(out "/hi_route_roles_summary.txt"))
  fprintf(f "actualEtchLines=%d\nthermalReliefLines=%d\nclassification=line.thermal_OR_parent_path.thermal\nHI_ROUTE_ROLES_COMPLETE\n" count thermalCount)
  close(f) t))

procedure(hiBindExistingShapeByBBox(f id net layer bbox)
 let((found)
  found=setof(s axlDBGetShapes("BOUNDARY")
    s->net && equal(s->net->name net) && equal(s->layer strcat("BOUNDARY/" layer)) && equal(s->bBox bbox))
  unless(length(found)==1 error("Dynamic reference boundary not unique for %s bbox=%L found=%L\n" id bbox found))
  fprintf(f "HI_BIND_EXISTING_SHAPE_BY_BBOX id=%L layer=%L bbox=%L actual=%L\n" id layer bbox car(found)->??)
  hiReg(id "shape" car(found))
  car(found)))

procedure(hiReferenceCoverageRead(out step)
 let((f seen layers four pnet refLayer shapes a b dx dy len n xy app quiet manualCount sampleCount p)
  f=outfile(strcat(out "/hi_actual_reference_samples.tsv"))
  fprintf(f "net\tsignalLayer\treferenceLayer\tsegmentStartEnd\twidth\tfraction\txy\tapplicationDynamicCount\tstaticQuietCount\n")
  layers=axlSubclassRoute() four=length(layers)==4
  seen=nil manualCount=0 sampleCount=0
  foreach(o axlExtractMap("C:/Program0/Cadence/SPB172/share/pcb/text/views/fgeo_bv.txt" nil)
   unless(member(o seen)
    seen=cons(o seen)
    p=o->parent
    when(equal(o->objType "line") && o->isEtch && o->net && !equal(o->net->name "GND") && !o->thermal && !(p && p->thermal) && member(o->layer list("ETCH/TOP" "ETCH/BOTTOM"))
     refLayer=if(four then if(equal(o->layer "ETCH/TOP") then "ETCH/L2" else "ETCH/L3") else if(equal(o->layer "ETCH/TOP") then "ETCH/BOTTOM" else "ETCH/TOP"))
     shapes=setof(s axlDBGetShapes(refLayer) s->fill && s->net && equal(s->net->name "GND") && !s->shapeIsBoundary)
     a=car(o->startEnd) b=cadr(o->startEnd)
     dx=car(b)-car(a) dy=cadr(b)-cadr(a) len=sqrt(dx*dx+dy*dy)
     n=max(1 fix(len/step)+1) manualCount=manualCount+1
     for(i 0 n
      xy=list(car(a)+dx*i*1.0/n cadr(a)+dy*i*1.0/n)
      app=0 quiet=0
      foreach(s shapes
       when(axlGeoPointInShape(xy s t)
        if(s->shapeBoundary then app=app+1 else quiet=quiet+1)))
      fprintf(f "%L\t%L\t%L\t%L\t%L\t%L\t%L\t%d\t%d\n" o->net->name o->layer refLayer o->startEnd o->width i*1.0/n xy app quiet)
      sampleCount=sampleCount+1))))
  close(f)
  f=outfile(strcat(out "/hi_actual_reference_samples_scope.txt"))
  fprintf(f "HI_ACTUAL_REFERENCE_SAMPLES_COMPLETE\nmanualNonGroundSegments=%d\nsampleCount=%d\nmaxCenterlineStepMM=%L\nmethod=axlGeoPointInShape(point,actualGeneratedOrStaticETCHShape,t); t excludes actual voids\nscope=Geometric centerline reference coverage only; not proof of adequate HF return impedance, continuous wider field support, island topology, via transition quality or SI/EMI certification.\nclassification=Application dynamic GND vs local static quiet GND kept separate. Quiet island is appropriate only for the explicitly planned oscillator network, not arbitrary nets.\n" manualCount sampleCount step)
  close(f) t))

procedure(hiBranchAudit(out)
 let((f allpins graph terminals seen orphanCount branchCount refs)
  f=outfile(strcat(out "/hi_branch_terminal_audit.txt"))
  allpins=nil orphanCount=0 branchCount=0
  foreach(c axlDBGetDesign()->components
   foreach(p c->symbol->pins when(p->net && member(p->net axlDBGetDesign()->nets) allpins=cons(p allpins))))
  foreach(net axlDBGetDesign()->nets
   foreach(branch net->branches
    graph=nil
    foreach(child branch->children
     foreach(obj gConnectedObjects(child) unless(member(obj graph) graph=cons(obj graph))))
    terminals=setof(p allpins member(p graph))
    refs=mapcar('hiTerminalKey terminals)
    branchCount=branchCount+1
    fprintf(f "BRANCH_AUDIT net=%L branch=%L children=%d reachableObjects=%d physicalTerminals=%d terminalKeys=%L\n" net->name branch length(branch->children) length(graph) length(terminals) refs)
    unless(terminals
     orphanCount=orphanCount+1
     fprintf(f "NO_TERMINAL_BRANCH net=%L branchAttrs=%L\n" net->name branch->??)
     foreach(obj graph fprintf(f "NO_TERMINAL_OBJECT net=%L object=%L attrs=%L\n" net->name obj obj->??)))))
  fprintf(f "HI_BRANCH_TERMINAL_AUDIT_COMPLETE\nbranches=%d\nbranchesWithoutPhysicalTerminals=%d\nscope=Physical branch reachability, not by itself manufacturing or antenna certification.\n" branchCount orphanCount)
  close(f) t))

; Connectivity-aware reference sampling override; historical immutable readbacks retain their original version.
procedure(hiReferenceCoverageRead(out step)
 let((f seen layers four pnet refLayer shapes a b dx dy len n xy app quiet manualCount sampleCount p globalGraph connected floating)
  f=outfile(strcat(out "/hi_actual_reference_samples.tsv"))
  fprintf(f "net\tsignalLayer\treferenceLayer\tsegmentStartEnd\twidth\tfraction\txy\tapplicationDynamicCount\tstaticQuietCount\tapplicationGlobalConnectedCount\tapplicationWithoutGlobalPinConnectionCount\n")
  layers=axlSubclassRoute() four=length(layers)==4
  seen=nil manualCount=0 sampleCount=0 globalGraph=gConnectedObjects(gPin("U1" "47"))
  foreach(o axlExtractMap("C:/Program0/Cadence/SPB172/share/pcb/text/views/fgeo_bv.txt" nil)
   unless(member(o seen)
    seen=cons(o seen)
    p=o->parent
    when(equal(o->objType "line") && o->isEtch && o->net && !equal(o->net->name "GND") && !o->thermal && !(p && p->thermal) && member(o->layer list("ETCH/TOP" "ETCH/BOTTOM"))
     refLayer=if(four then if(equal(o->layer "ETCH/TOP") then "ETCH/L2" else "ETCH/L3") else if(equal(o->layer "ETCH/TOP") then "ETCH/BOTTOM" else "ETCH/TOP"))
     shapes=setof(s axlDBGetShapes(refLayer) s->fill && s->net && equal(s->net->name "GND") && !s->shapeIsBoundary)
     a=car(o->startEnd) b=cadr(o->startEnd)
     dx=car(b)-car(a) dy=cadr(b)-cadr(a) len=sqrt(dx*dx+dy*dy)
     n=max(1 fix(len/step)+1) manualCount=manualCount+1
     for(i 0 n
      xy=list(car(a)+dx*i*1.0/n cadr(a)+dy*i*1.0/n)
      app=0 quiet=0 connected=0 floating=0
      foreach(s shapes
       when(axlGeoPointInShape(xy s t)
        if(s->shapeBoundary then
         app=app+1
         if(member(s globalGraph) then connected=connected+1 else floating=floating+1)
        else quiet=quiet+1)))
      fprintf(f "%L\t%L\t%L\t%L\t%L\t%L\t%L\t%d\t%d\t%d\t%d\n" o->net->name o->layer refLayer o->startEnd o->width i*1.0/n xy app quiet connected floating)
      sampleCount=sampleCount+1))))
  close(f)
  f=outfile(strcat(out "/hi_actual_reference_samples_scope.txt"))
  fprintf(f "HI_ACTUAL_REFERENCE_SAMPLES_COMPLETE\nmanualNonGroundSegments=%d\nsampleCount=%d\nmaxCenterlineStepMM=%L\nmethod=axlGeoPointInShape(point,actualGeneratedOrStaticETCHShape,t); t excludes actual voids\nscope=Geometric centerline reference coverage only; not proof of adequate HF return impedance, continuous wider field support, island topology, via transition quality or SI/EMI certification.\nclassification=Application dynamic GND vs local static quiet GND kept separate. Dynamic GND shapes additionally distinguished by actual graph reachability to application pin U1.47; same net label alone is not sufficient. Quiet island is appropriate only for the explicitly planned oscillator network, not arbitrary nets.\n" manualCount sampleCount step)
  close(f) t))

procedure(hiGroundPointCheck(f id xy topConnected bottomConnected)
 let((graph shapes expected actual)
  axlShapeDynamicUpdate(nil t) axlDBRefreshId(nil)
  graph=gConnectedObjects(gPin("U1" "23"))
  foreach(layer list("TOP" "BOTTOM")
   expected=if(equal(layer "TOP") then topConnected else bottomConnected)
   shapes=setof(s axlDBGetShapes(strcat("ETCH/" layer)) s->fill && s->net && equal(s->net->name "GND") && !s->shapeIsBoundary && axlGeoPointInShape(xy s t))
   unless(length(shapes)==1 error("Ground stitch point must be inside exactly one actual filled GND shape on each layer, layer=%L shapes=%L\n" layer shapes))
   unless(car(shapes)->shapeBoundary error("Ground stitch point must be in application dynamic copper, not static quiet island\n"))
   actual=if(member(car(shapes) graph) then t else nil)
   fprintf(f "HI_GROUND_POINT_CHECK id=%L layer=%L xy=%L bbox=%L globalPin=U1.23 expectedConnected=%L actualConnected=%L shapeAttrs=%L\n" id layer xy car(shapes)->bBox expected actual car(shapes)->??)
   unless(equal(expected actual) error("Application ground shape connectivity does not match intended stitch pre/post condition\n")))
  t))

; Instrument exact unchanged all-on-plus-batch DRC request and result.
procedure(hiFinalize(f out board lib proofs)
 let((count drcResult)
  unless(equal(axlShapeDynamicUpdate(nil t) 0) error("Actual shape update failed\n"))
  axlDBRefreshId(nil)
  fprintf(f "HI_FULL_DRC_REQUEST_BEGIN time=%L g_mode=t online=%L physicalModes=%L spacingModes=%L electricalModes=%L\n" getCurrentTime() axlDBControl('drcEnable) axlCNSPhysicalModeGet('all) axlCNSSpacingModeGet('all) axlCNSEcsetModeGet('all)) drain(f)
  drcResult=axlDRCUpdate(t)
  fprintf(f "HI_FULL_DRC_REQUEST_RETURN time=%L result=%L online=%L storedDRCs=%d\n" getCurrentTime() drcResult axlDBControl('drcEnable) length(axlDBGetDesign()->drcs)) drain(f)
  unless(numberp(drcResult) error("Full DRC update returned nil/non-numeric; stored zero cannot be accepted as recomputed zero\n"))
  f29DumpDRC(f "HI_BATCH_FINAL")
  count=length(axlDBGetDesign()->drcs)
  foreach(p proofs hiProof(f car(p) cadr(p) caddr(p)))
  unless(axlSaveDesign(?design board ?noMru t ?noConfirm t) error("Cannot save HI candidate checkpoint\n"))
  fprintf(f "HI_BATCH_COMPLETED drcCount=%d status=%s board=%L\n" count if(count==0 then "CANDIDATE_DRC_ZERO_NOT_ENGINEERING_RELEASE" else "CANDIDATE_FAILED_DRC") board)
  close(f)
  gSnapshot(out lib)
  hiNetworkInventory(out)
  t))

procedure(hiMechanicalPinRead(out)
 let((f pf sf ps pad)
  f=outfile(strcat(out "/hi_mechanical_pins.tsv"))
  pf=outfile(strcat(out "/hi_mechanical_pad_layers.tsv"))
  sf=outfile(strcat(out "/hi_hole_spacing_defaults.tsv"))
  fprintf(f "symbol\trefdes\tpin\tpadstack\txy\tthrough\tmechanical\tholeType\tplating\tdrillDiameter\tdrillX\tdrillY\tdefinitionAttributes\tinstanceAttributes\n")
  fprintf(pf "refdes\tpin\tpadstack\txy\tlayer\tkind\tfigure\tpadBBoxRelativeXY\tpadAttributes\n")
  foreach(s axlDBGetDesign()->symbols
   foreach(p s->pins
    when(p->isMech || !p->number || equal(p->number "")
     ps=p->definition
     fprintf(f "%L\t%L\t%L\t%L\t%L\t%L\t%L\t%L\t%L\t%L\t%L\t%L\t%L\t%L\n" s->name s->refdes p->number p->name p->xy p->isThrough p->isMech ps->holeType ps->plating ps->drillDiameter ps->drillSizeWidth ps->drillSizeHeight ps->?? p->??)
     foreach(layer mapcar(lambda((l) strcat("ETCH/" l)) axlSubclassRoute())
      foreach(kind list("REGULAR" "ANTI" "THERMAL" "KEEPOUT")
       pad=axlDBGetPad(p layer kind)
       fprintf(pf "%L\t%L\t%L\t%L\t%L\t%L\t%L\t%L\t%L\n" s->refdes p->number p->name p->xy layer kind if(pad then pad->figureName else nil) if(pad then pad->bBox else nil) if(pad then pad->?? else nil)))))))
  fprintf(sf "cset\tlayer\tfield\tvalue\n")
  foreach(layer axlSubclassRoute()
   foreach(key list('hole_line 'hole_shape 'hole_via 'hole_hole 'hole_thrupin)
    fprintf(sf "DEFAULT\t%L\t%L\t%L\n" layer key axlCNSGetSpacing("DEFAULT" layer key))))
  foreach(port list(f pf sf) close(port))
  f=outfile(strcat(out "/hi_mechanical_pin_scope.txt"))
  fprintf(f "HI_ALL_MECHANICAL_PINS_READ_COMPLETE\nAll actual symbol pins with isMech or empty/nil number included, including connector locating holes. Hole geometry taken from embedded native padstack definition, not inferred from name. Only actual routing layers probed. DEFAULT spacing is raw reference data, not a coordinate-specific resolved rule for a hole against another net/class.\n") close(f) t))

procedure(hiAllVias()
 let((seen result)
  seen=nil result=nil
  foreach(v axlExtractMap("C:/Program0/Cadence/SPB172/share/pcb/text/views/fgeo_bv.txt" nil)
   unless(member(v seen) seen=cons(v seen) when(equal(v->objType "via") result=cons(v result))))
  result))
procedure(hiUniqueVia(net xy padstack)
 let((found)
  found=setof(v hiAllVias() v->net && equal(v->net->name net) && equal(v->xy xy) && equal(upperCase(v->name) upperCase(padstack)))
  unless(length(found)==1 error("Via selection is not unique for net=%L xy=%L padstack=%L found=%L\n" net xy padstack found))
  car(found)))
procedure(hiViaIdentity(v)
 list(v->xy upperCase(v->name) if(v->net then v->net->name else nil)))
procedure(hiDeleteVia(f id net xy padstack)
 let((target before others after)
  target=hiUniqueVia(net xy padstack) before=hiAllVias()
  others=mapcar('hiViaIdentity setof(v before !equal(v target)))
  fprintf(f "HI_DELETE_VIA_EXACT_BEGIN id=%L countBefore=%d target=%L attrs=%L\n" id length(before) target target->??)
  unless(axlDeleteObject(target) error("Cannot delete uniquely selected via\n"))
  axlDBRefreshId(nil) after=hiAllVias()
  unless(length(after)==length(before)-1 error("Via deletion affected unexpected instance count\n"))
  when(setof(v after equal(v->xy xy) && equal(upperCase(v->name) upperCase(padstack))) error("Selected via still physically exists\n"))
  foreach(sig others unless(member(sig mapcar('hiViaIdentity after)) error("Unrelated via identity changed during exact deletion\n")))
  fprintf(f "HI_DELETE_VIA_EXACT_COMPLETE id=%L net=%L xy=%L padstack=%L countAfter=%d otherViaSignaturesUnchanged=t\n" id net xy padstack length(after))
  t))
procedure(hiDeleteViaRollbackPilot(out)
 let((f mark before target)
  f=outfile(strcat(out "/hi_delete_via_rollback.txt"))
  before=length(hiAllVias()) target=hiUniqueVia("GPIO_PC14" list(45.6 25.2) "L28_VIA030_C060")
  unless(member(target gConnectedObjects(gPin("U1" "3"))) error("PC14 source does not reach selected old via\n"))
  fprintf(f "INITIAL count=%d drcEnable=%L storedDRCs=%d actualVia=%L\n" before axlDBControl('drcEnable) length(axlDBGetDesign()->drcs) target->??)
  mark=axlDBTransactionStart()
  unwindProtect(progn(
   axlDBControl('drcEnable nil)
   hiDeleteVia(f "PILOT_PC14_ONLY_VIA" "GPIO_PC14" list(45.6 25.2) "L28_VIA030_C060")
   fprintf(f "WHILE_DELETED selectedViaCount=0 otherViaCount=%d storedDRCNotRecomputed=t\n" length(hiAllVias()))
   t) progn(unless(axlDBTransactionRollback(mark) error("Via deletion rollback failed\n")) axlDBControl('drcEnable t)))
  target=hiUniqueVia("GPIO_PC14" list(45.6 25.2) "L28_VIA030_C060")
  unless(before==length(hiAllVias()) && member(target gConnectedObjects(gPin("U1" "3"))) error("Rollback did not restore exact count and PC14 source graph\n"))
  fprintf(f "ROLLBACK_RESTORED count=%d sourcePinU1_3ReachesOriginalVia=t drcEnable=%L\nHI_DELETE_VIA_ROLLBACK_PILOT_COMPLETE_NO_SAVE_NO_FULL_DRC_REQUEST\n" length(hiAllVias()) axlDBControl('drcEnable)) close(f) t))

procedure(hiPolygonMatches(obj points)
 prog((poly vertices actual n ok found)
  poly=car(axlPolyFromDB(obj))
  unless(poly return(nil))
  vertices=poly->vertices
  when(exists(v vertices abs(cadr(v))>0.0000001) return(nil))
  actual=mapcar('car vertices)
  when(length(actual)>1 && equal(car(actual) car(last(actual))) actual=reverse(cdr(reverse(actual))))
  when(length(points)>1 && equal(car(points) car(last(points))) points=reverse(cdr(reverse(points))))
  n=length(points) found=nil
  unless(length(actual)==n return(nil))
  foreach(order list(actual reverse(actual))
   for(offset 0 n-1
    ok=t
    for(k 0 n-1
     unless(abs(car(nth(mod(k+offset n) order))-car(nth(k points)))<0.00011 && abs(cadr(nth(mod(k+offset n) order))-cadr(nth(k points)))<0.00011 ok=nil))
    when(ok found=t)))
  return(found)))
procedure(hiUniqueExactShape(net layer polygon dynamic)
 let((found)
  found=setof(s axlDBGetShapes(strcat(if(dynamic then "BOUNDARY/" else "ETCH/") layer))
    s->net && equal(s->net->name net) && if(dynamic then s->shapeIsBoundary else !s->shapeBoundary && !s->shapeIsBoundary) && hiPolygonMatches(s polygon))
  unless(length(found)==1 error("Exact polygon shape is not uniquely selected net=%L layer=%L dynamic=%L found=%L\n" net layer dynamic found))
  car(found)))
procedure(hiReplaceExactShape(f id net layer oldPolygon newPolygon dynamic voids)
 let((target)
  target=hiUniqueExactShape(net layer oldPolygon dynamic)
  fprintf(f "HI_REPLACE_EXACT_SHAPE_OLD id=%L attrs=%L polygon=%L\n" id target->?? oldPolygon)
  unless(axlDeleteObject(target) error("Cannot remove exact old reference shape\n"))
  axlDBRefreshId(nil)
  when(setof(s axlDBGetShapes(strcat(if(dynamic then "BOUNDARY/" else "ETCH/") layer)) s->net && equal(s->net->name net) && hiPolygonMatches(s oldPolygon)) error("Old polygon was not removed before replacement\n"))
  hiShape(f id net layer newPolygon dynamic voids)
  target=hiUniqueExactShape(net layer newPolygon dynamic)
  fprintf(f "HI_REPLACE_EXACT_SHAPE_NEW id=%L attrs=%L polygon=%L\n" id target->?? newPolygon)
  target))
procedure(hiUniqueBoundaryByBBox(net layer bbox)
 let((found)
  found=setof(s axlDBGetShapes(strcat("BOUNDARY/" layer)) s->net && equal(s->net->name net) && equal(s->bBox bbox))
  unless(length(found)==1 error("Application boundary not unique by net/layer/bbox\n"))
  car(found)))
procedure(hiReplaceExactVoid(f id net layer bbox oldPolygon newPolygon)
 let((boundary candidates target beforeCount otherVoids)
  boundary=hiUniqueBoundaryByBBox(net layer bbox)
  candidates=setof(v boundary->voids hiPolygonMatches(v oldPolygon))
  unless(length(candidates)==1 error("Old permanent void not unique; refuse overlay\n"))
  target=car(candidates) beforeCount=length(boundary->voids) otherVoids=setof(v boundary->voids !equal(v target))
  fprintf(f "HI_REPLACE_PERMANENT_VOID_OLD id=%L boundary=%L target=%L attrs=%L oldPolygon=%L\n" id boundary target target->?? oldPolygon)
  unless(axlShapeDeleteVoids(target) error("Cannot delete exact old permanent void\n"))
  axlDBRefreshId(nil) boundary=hiUniqueBoundaryByBBox(net layer bbox)
  unless(length(boundary->voids)==beforeCount-1 error("Permanent void removal affected unexpected count\n"))
  when(setof(v boundary->voids hiPolygonMatches(v oldPolygon)) error("Old permanent void still exists\n"))
  foreach(v otherVoids unless(member(v boundary->voids) error("Unrelated permanent void changed\n")))
  hiReg(id "shape" boundary) hiVoid(f id newPolygon)
  boundary=hiUniqueBoundaryByBBox(net layer bbox)
  unless(length(boundary->voids)==beforeCount && length(setof(v boundary->voids hiPolygonMatches(v newPolygon)))==1 error("New exact permanent void not present once\n"))
  fprintf(f "HI_REPLACE_PERMANENT_VOID_NEW id=%L oldRemoved=t newUnique=t voidCount=%d newPolygon=%L\n" id length(boundary->voids) newPolygon)
  t))

procedure(hiCCSpacingChallenge(out)
 let((f name result hit hasCC)
  f=outfile(strcat(out "/hi_cc_spacing_challenge.txt")) name="HI_USB_CC1_J2_S_2L" hit=nil
  foreach(key list('smdpin_line 'line_line) unless(abs(axlCNSGetSpacing(name "TOP" key)-0.2)<0.00001 error("Unexpected baseline scopedCC spacing\n")))
  unwindProtect(progn(
   foreach(key list('smdpin_line 'line_line) unless(axlCNSSetSpacing(name nil key "0.4 MM") error("Cannot tighten scoped CC rule\n")))
   axlDBControl('drcEnable t)
   fprintf(f "CC_STRICT_REQUEST time=%L cset=%L twoFieldsNormal=.2 strict=.4 online=%L\n" getCurrentTime() name axlDBControl('drcEnable)) drain(f)
   result=axlDRCUpdate(t) fprintf(f "CC_STRICT_RETURN time=%L result=%L\n" getCurrentTime() result) f29DumpDRC(f "CC1_STRICT_040")
   unless(numberp(result) error("Strict scopedCC DRC did not return numeric result\n"))
   foreach(d axlDBGetDesign()->drcs
    hasCC=nil
    foreach(obj d->violations when(obj->net && equal(obj->net->name "USB_CC1") hasCC=t))
    when(hasCC && abs(atof(d->expected)-0.4)<0.00011 && abs(atof(d->actual)-0.3)<0.00011 hit=t fprintf(f "CC1_REAL_030_NATIVE_DRC=%L\n" d->??)))
   unless(hit error("Tightened CC1 rule did not catch planned real0.3mm gap\n"))
   t) progn(
    foreach(key list('smdpin_line 'line_line) unless(axlCNSSetSpacing(name nil key "0.2 MM") error("Cannot restore scopedCC rule\n")))
    result=axlDRCUpdate(t) fprintf(f "CC_RESTORED_RETURN time=%L result=%L storedDRCs=%d\n" getCurrentTime() result length(axlDBGetDesign()->drcs)) f29DumpDRC(f "CC1_RESTORED_020")
    unless(numberp(result) && length(axlDBGetDesign()->drcs)==0 error("Restored scoped CC rule did not recover zeroDRC\n"))))
  fprintf(f "CC1_SPACING_CHALLENGE_COMPLETE_REAL030_CAUGHT_THEN_RESTORED020_NO_GLOBAL_RELAXATION\n") close(f) t))

procedure(hiCCSpacingChallenge(out)
 let((f name result hit hasCC net)
  f=outfile(strcat(out "/hi_cc_spacing_challenge.txt")) name="HI_USB_CC1_J2_S_2L" hit=nil net=axlDBFindByName('net "USB_CC1")
  unless(net error("CC1 challenge target net absent\n"))
  foreach(key list('smdpin_line 'line_line) unless(abs(axlCNSGetSpacing(name "TOP" key)-0.2)<0.00001 error("Unexpected baseline scopedCC spacing\n")))
  unwindProtect(progn(
   foreach(key list('smdpin_line 'line_line) unless(axlCNSSetSpacing(name nil key "0.4 MM") error("Cannot tighten scoped CC rule\n")))
   axlDBControl('drcEnable t)
   fprintf(f "CC_STRICT_REQUEST scope=USB_CC1_ONLY_API_axlDRCItem_nil time=%L cset=%L twoFieldsNormal=.2 strict=.4 online=%L\n" getCurrentTime() name axlDBControl('drcEnable)) drain(f)
   result=axlDRCItem(nil net) fprintf(f "CC_STRICT_RETURN time=%L result=%L\n" getCurrentTime() result) f29DumpDRC(f "CC1_STRICT_040")
   unless(numberp(result) error("Strict scopedCC DRC did not return numeric result\n"))
   foreach(d axlDBGetDesign()->drcs
    hasCC=nil
    foreach(obj d->violations when(obj->net && equal(obj->net->name "USB_CC1") hasCC=t))
    when(hasCC && abs(atof(d->expected)-0.4)<0.00011 && abs(atof(d->actual)-0.3)<0.00011 hit=t fprintf(f "CC1_REAL_030_NATIVE_DRC=%L\n" d->??)))
   unless(hit error("Tightened CC1 rule did not catch planned real0.3mm gap\n"))
   t) progn(
    foreach(key list('smdpin_line 'line_line) unless(axlCNSSetSpacing(name nil key "0.2 MM") error("Cannot restore scopedCC rule\n")))
    result=axlDRCItem(nil net) fprintf(f "CC_RESTORED_RETURN time=%L result=%L storedDRCs=%d\n" getCurrentTime() result length(axlDBGetDesign()->drcs)) f29DumpDRC(f "CC1_RESTORED_020")
    unless(numberp(result) && result==0 error("Restored scoped CC rule did not recover zero DRC on USB_CC1\n"))))
  fprintf(f "CC1_SPACING_CHALLENGE_COMPLETE_REAL030_CAUGHT_THEN_RESTORED020_SCOPED_NET_ONLY_FULL_BOARD_CHECK_FOLLOWS\n") close(f) t))

procedure(hiSpacingFieldsUpdate(f name values)
 let((before after layers changed)
  layers=cons(nil axlGetParam("paramLayerGroup:ETCH")->groupMembers) before=nil changed=mapcar('car values)
  foreach(layer layers before=cons(list(layer axlCNSGetSpacing(name layer 'all)) before))
  fprintf(f "HI_EXISTING_SPACING_FIELDS_BEFORE cset=%L allowedKeys=%L snapshots=%L\n" name changed before)
  foreach(row values unless(axlCNSSetSpacing(name nil car(row) cadr(row)) error("Cannot update existing finite-region spacing field\n")))
  foreach(row before
   after=axlCNSGetSpacing(name car(row) 'all)
   foreach(old cadr(row)
    unless(member(car(old) changed)
     unless(equal(old assoc(car(old) after)) error("Unrequested spacing field changed while updating finite-region CSet\n"))))
   fprintf(f "HI_EXISTING_SPACING_FIELDS_AFTER cset=%L layer=%L values=%L\n" name car(row) after))
  fprintf(f "HI_EXISTING_SPACING_ONLY_DECLARED_KEYS_CHANGED cset=%L allowedKeys=%L\n" name changed) t))

procedure(hiSpacingFieldsUpdate(f name values)
 let((before after layers changed)
  layers=axlGetParam("paramLayerGroup:ETCH")->groupMembers before=nil changed=mapcar('car values)
  foreach(layer layers before=cons(list(layer axlCNSGetSpacing(name layer nil)) before))
  foreach(row before unless(cadr(row) error("Full spacing snapshot unexpectedly nil; refuse empty comparison\n")))
  fprintf(f "HI_EXISTING_SPACING_FIELDS_BEFORE cset=%L allowedKeys=%L snapshots=%L\n" name changed before)
  foreach(row values unless(axlCNSSetSpacing(name nil car(row) cadr(row)) error("Cannot update existing finite-region spacing field\n")))
  foreach(row before
   after=axlCNSGetSpacing(name car(row) nil)
   foreach(old cadr(row)
    unless(member(car(old) changed)
     unless(equal(old assoc(car(old) after)) error("Unrequested spacing field changed while updating finite-region CSet\n"))))
   fprintf(f "HI_EXISTING_SPACING_FIELDS_AFTER cset=%L layer=%L values=%L\n" name car(row) after))
  fprintf(f "HI_EXISTING_SPACING_ONLY_DECLARED_KEYS_CHANGED cset=%L allowedKeys=%L\n" name changed) t))

procedure(hiPhysicalTerminalContract(f expected)
 let((actualCount realCount pin actualNet des)
  des=axlDBGetDesign() actualCount=0 realCount=0
  foreach(c des->components foreach(p c->symbol->pins
   unless(p->isMech || !p->number || equal(p->number "") actualCount=actualCount+1)))
  unless(actualCount==length(expected) error("Actual physical logical pin count differs from stable terminal contract\n"))
  foreach(row expected
   pin=gPin(car(row) cadr(row))
   actualNet=if(pin->net && member(pin->net des->nets) then pin->net->name else nil)
   unless(equal(actualNet caddr(row)) && equal(pin->name cadddr(row)) error("Stable physical pin net/padstack identity changed ref=%L pin=%L expectedNet=%L actualNet=%L\n" car(row) cadr(row) caddr(row) actualNet))
   when(actualNet realCount=realCount+1)
   fprintf(f "PHYSICAL_PIN_CONTRACT ref=%L pin=%L net=%L padstack=%L actualXY=%L\n" car(row) cadr(row) actualNet pin->name pin->xy))
  fprintf(f "HI_PHYSICAL_TERMINAL_CONTRACT_COMPLETE physicalPins=%d namedNetPins=%d ncPseudoPins=%d\n" actualCount realCount actualCount-realCount)
  t))

procedure(hiSpacingLayerFieldsUpdate(f name updates)
 let((before layers after allowed value requested)
  layers=axlGetParam("paramLayerGroup:ETCH")->groupMembers before=nil
  foreach(layer layers
   value=axlCNSGetSpacing(name layer nil)
   unless(value error("Existing spacing full-field snapshot nil; abort\n"))
   before=cons(list(layer value) before))
  fprintf(f "HI_EXISTING_SPACING_LAYER_FIELDS_BEFORE name=%L allowedTriples=%L snapshots=%L\n" name updates before)
  foreach(row updates
   unless(member(car(row) layers) error("Requested spacing update layer is not actual conductor\n"))
   unless(axlCNSSetSpacing(name car(row) cadr(row) caddr(row)) error("Cannot apply finite layer-specific spacing field\n")))
  foreach(row before
   after=axlCNSGetSpacing(name car(row) nil)
   unless(after error("Spacing field snapshot became nil\n"))
   foreach(old cadr(row)
    allowed=exists(u updates equal(car(u) car(row)) && equal(cadr(u) car(old)))
    unless(allowed unless(equal(old assoc(car(old) after)) error("Undeclared spacing field/layer changed\n"))))
   fprintf(f "HI_EXISTING_SPACING_LAYER_FIELDS_AFTER name=%L layer=%L allValues=%L\n" name car(row) after))
  foreach(row updates
   requested=if(numberp(caddr(row)) then caddr(row) else atof(caddr(row)))
   value=axlCNSGetSpacing(name car(row) cadr(row))
   unless(numberp(value) && abs(value-requested)<0.00001 error("Declared spacing change did not read back correctly\n")))
  fprintf(f "HI_EXISTING_SPACING_LAYER_UPDATE_ONLY_DECLARED_TRIPLES_CHANGED name=%L updates=%L\n" name updates) t))

procedure(hiFiniteViaLineChallenge(out name layer netName normal strict)
 let((f net result hit hasNet before after)
  f=outfile(strcat(out "/hi_finite_via_line_challenge.txt")) net=axlDBFindByName('net netName) hit=nil
  unless(net error("Scoped challenge target net absent\n"))
  before=axlCNSGetSpacing(name layer nil)
  unless(before && abs(axlCNSGetSpacing(name layer 'via_line)-normal)<0.00001 error("Unexpected finite via_line baseline\n"))
  unwindProtect(progn(
   unless(axlCNSSetSpacing(name layer 'via_line strict) error("Cannot tighten finite via_line\n"))
   axlDBControl('drcEnable t)
   fprintf(f "FINITE_VIA_LINE_STRICT_REQUEST cset=%L layer=%L net=%L normal=%L strict=%L scope=one_actual_net_API_axlDRCItem time=%L online=%L\n" name layer netName normal strict getCurrentTime() axlDBControl('drcEnable)) drain(f)
   result=axlDRCItem(nil net)
   fprintf(f "FINITE_VIA_LINE_STRICT_RESULT count=%L time=%L\n" result getCurrentTime())
   unless(numberp(result) && result>0 error("Strict finite via_line did not produce native scoped DRC\n"))
   foreach(d axlDBGetDesign()->drcs
    when(d->objType && equal(d->source name)
     hasNet=nil foreach(obj d->violations when(obj->net && equal(obj->net->name netName) hasNet=t))
     when(hasNet && abs(atof(d->expected)-strict)<0.00011 && atof(d->actual)>=normal-0.00011 && atof(d->actual)<strict-0.00011
      hit=t fprintf(f "ACTUAL_FINITE_VIA_LINE_NATIVE_VIOLATION %L\n" d->??))))
   unless(hit error("Strict finite via_line did not catch actual gap between normal and strict\n"))
   t) progn(
    unless(axlCNSSetSpacing(name layer 'via_line normal) error("Cannot restore finite via_line\n"))
    axlDBControl('drcEnable t) result=axlDRCItem(nil net)
    fprintf(f "FINITE_VIA_LINE_RESTORED cset=%L layer=%L result=%L normalReadback=%L time=%L online=%L\n" name layer result axlCNSGetSpacing(name layer 'via_line) getCurrentTime() axlDBControl('drcEnable))
    unless(numberp(result) && result==0 error("Restored finite via_line did not recover zero on target net\n"))))
  after=axlCNSGetSpacing(name layer nil)
  unless(equal(before after) error("Scoped via_line challenge did not restore exact complete spacing layer record\n"))
  fprintf(f "HI_FINITE_VIA_LINE_SCOPED_NEGATIVE_COMPLETE_RULE_RESTORED_FULL_BOARD_CHECK_REQUIRED\n") close(f) t))
