procedure(hiBatchProgram()
 let((f)
  f=outfile("D:/001DIY/005lib/01AIEDA/learning/examples/lessonHI_38_50_20261021/logs/USB_aux_4L_b014/hi_batch_execution.txt")
  fprintf(f "HI_BATCH_DRC_BEFORE=%L\n" axlDBControl('drcEnable))
  unwindProtect(
   progn(
    axlDBControl('drcEnable nil)
    fprintf(f "HI_ASSEMBLY_ONLINE_DRC_TEMPORARILY_DISABLED=%L\n" axlDBControl('drcEnable))
    hiRegistry=nil
    hiNodeDefinitions=list(list("HI_4L_USB_PULLUP_SRC_1_R1" "USB_PULLUP_SRC" "TOP" list(42.8748 14.6) "point") list("HI_4L_VBUS_GATE_1_R1" "VBUS_GATE" "TOP" list(50.6764 7.0) "point") list("HI_4L_VBUS_GATE_2_R1" "VBUS_GATE" "TOP" list(56.2 9.1016) "point") list("HI_4L_VBUS_PRESENT_N_1_R1" "VBUS_PRESENT_N" "TOP" list(56.2 14.6764) "point") list("HI_4L_USB_ATTACH_N_1_V1" "USB_ATTACH_N" "TOP" list(50.8 16.3) "via") list("HI_4L_USB_ATTACH_N_1_V2" "USB_ATTACH_N" "TOP" list(47.95 13.45) "via") list("HI_4L_USB_ATTACH_N_1_R1" "USB_ATTACH_N" "TOP" list(50.1764 17.2) "point") list("HI_4L_USB_ATTACH_N_1_R2" "USB_ATTACH_N" "BOTTOM" list(50.8 16.3) "point") list("HI_4L_USB_ATTACH_N_1_R3" "USB_ATTACH_N" "TOP" list(47.95 13.45) "point") list("HI_4L_UART_RX_1_R1" "UART_RX" "TOP" list(68.1016 25.0) "point") list("CC1_ENTRY" "USB_CC1" "TOP" list(38.75 7.355) "point") list("CC2_ENTRY" "USB_CC2" "TOP" list(41.75 7.355) "point") list("CC_R3_GND" "GND" "TOP" list(35.0 11.6764) "point") list("CC_R3_GND_V" "GND" "TOP" list(36.1 11.6764) "via") list("CC_R4_GND" "GND" "TOP" list(45.5 11.6764) "point") list("CC2_ENTRY_V" "USB_CC2" "TOP" list(41.75 8.3) "via") list("CC2_BOTTOM_CROSSOVER" "USB_CC2" "BOTTOM" list(41.75 8.3) "point") list("CC2_RECEIVER_V" "USB_CC2" "TOP" list(44.7 10.1016) "via") list("CC2_RECEIVER_TOP" "USB_CC2" "TOP" list(44.7 10.1016) "point") list("VBUS_LEFT_ESCAPE" "USB_VBUS" "TOP" list(37.6 7.355) "point") list("VBUS_LEFT_V" "USB_VBUS" "TOP" list(36.9 9.2) "via") list("VBUS_LEFT_LAYER3_REFERENCED_BRIDGE" "USB_VBUS" "BOTTOM" list(36.9 9.2) "point") list("VBUS_RIGHT_ESCAPE" "USB_VBUS" "TOP" list(42.4 7.355) "point") list("VBUS_SENSE_DIRECT_TOP" "USB_VBUS" "TOP" list(42.7 9.2016) "point") list("APP_RETURN_HI_4L_USB_ATTACH_N_1_V1" "GND" "TOP" list(51.411 17.028) "via") list("APP_RETURN_HI_4L_USB_ATTACH_N_1_V2" "GND" "TOP" list(47.0 13.45) "via") list("APP_RETURN_VBUS_LEFT_V" "GND" "TOP" list(36.077 8.725) "via"))
    hiRoute(f "HI_4L_USB_PULLUP_SRC_1_R1" "USB_PULLUP_SRC" "TOP" list(list(42.8748 14.6) list(47.85 14.6) list(48.0 14.7718)) list(0.2 0.2))
    hiRoute(f "HI_4L_VBUS_GATE_1_R1" "VBUS_GATE" "TOP" list(list(50.6764 7.0) list(50.7 9.2) list(51.0475 9.5282)) list(0.2 0.2))
    hiRoute(f "HI_4L_VBUS_GATE_2_R1" "VBUS_GATE" "TOP" list(list(56.2 9.1016) list(54.25 9.1) list(53.6 8.45) list(52.15 8.45) list(51.0475 9.5282)) list(0.2 0.2 0.2 0.2))
    hiRoute(f "HI_4L_VBUS_PRESENT_N_1_R1" "VBUS_PRESENT_N" "TOP" list(list(56.2 14.6764) list(53.9 14.7) list(52.0 12.8) list(52.0 12.0718)) list(0.2 0.2 0.2))
    hiVia(f "HI_4L_USB_ATTACH_N_1_V1" "USB_ATTACH_N" list(50.8 16.3) "L28_VIA030_C060")
    hiVia(f "HI_4L_USB_ATTACH_N_1_V2" "USB_ATTACH_N" list(47.95 13.45) "L28_VIA030_C060")
    hiRoute(f "HI_4L_USB_ATTACH_N_1_R1" "USB_ATTACH_N" "TOP" list(list(50.1764 17.2) list(50.2 16.9) list(50.8 16.3)) list(0.2 0.2))
    hiRoute(f "HI_4L_USB_ATTACH_N_1_R2" "USB_ATTACH_N" "BOTTOM" list(list(50.8 16.3) list(47.95 13.45)) list(0.2))
    hiRoute(f "HI_4L_USB_ATTACH_N_1_R3" "USB_ATTACH_N" "TOP" list(list(47.95 13.45) list(47.95 13.15) list(47.0475 12.2282)) list(0.2 0.2))
    hiRoute(f "HI_4L_UART_RX_1_R1" "UART_RX" "TOP" list(list(68.1016 25.0) list(69.35 23.75) list(74.0 23.73)) list(0.2 0.2))
    hiRoute(f "CC1_ENTRY" "USB_CC1" "TOP" list(list(38.75 7.355) list(38.75 8.3) list(36.9484 10.1016) list(35.0 10.1016)) list(0.2 0.2 0.2))
    hiRoute(f "CC2_ENTRY" "USB_CC2" "TOP" list(list(41.75 7.355) list(41.75 8.3)) list(0.2))
    hiRoute(f "CC_R3_GND" "GND" "TOP" list(list(35.0 11.6764) list(36.1 11.6764)) list(0.6))
    hiVia(f "CC_R3_GND_V" "GND" list(36.1 11.6764) "L28_VIA030_C060")
    hiRoute(f "CC_R4_GND" "GND" "TOP" list(list(45.5 11.6764) list(43.9 11.6764) list(43.8 11.5764)) list(0.6 0.6))
    hiVia(f "CC2_ENTRY_V" "USB_CC2" list(41.75 8.3) "L28_VIA030_C060")
    hiRoute(f "CC2_BOTTOM_CROSSOVER" "USB_CC2" "BOTTOM" list(list(41.75 8.3) list(41.95 8.5) list(44.0 8.5) list(44.7 9.2) list(44.7 10.1016)) list(0.2 0.2 0.2 0.2))
    hiVia(f "CC2_RECEIVER_V" "USB_CC2" list(44.7 10.1016) "L28_VIA030_C060")
    hiRoute(f "CC2_RECEIVER_TOP" "USB_CC2" "TOP" list(list(44.7 10.1016) list(45.5 10.1016)) list(0.2))
    hiRoute(f "VBUS_LEFT_ESCAPE" "USB_VBUS" "TOP" list(list(37.6 7.355) list(37.6 8.2) list(36.9 8.9) list(36.9 9.2)) list(0.4 0.4 0.4))
    hiVia(f "VBUS_LEFT_V" "USB_VBUS" list(36.9 9.2) "L28_VIA030_C060")
    hiRoute(f "VBUS_LEFT_LAYER3_REFERENCED_BRIDGE" "USB_VBUS" "BOTTOM" list(list(36.9 9.2) list(40.15 9.2) list(40.25 9.3)) list(0.4 0.4))
    hiRoute(f "VBUS_RIGHT_ESCAPE" "USB_VBUS" "TOP" list(list(42.4 7.355) list(42.4 7.97) list(42.4 8.2) list(42.7 8.5) list(42.7 9.2016)) list(0.4 0.2 0.2 0.4))
    hiRoute(f "VBUS_SENSE_DIRECT_TOP" "USB_VBUS" "TOP" list(list(42.7 9.2016) list(43.3 8.6016) list(46.0 8.6016) list(47.6016 7.0) list(49.1016 7.0)) list(0.4 0.4 0.4 0.4))
    hiVia(f "APP_RETURN_HI_4L_USB_ATTACH_N_1_V1" "GND" list(51.411 17.028) "L28_VIA030_C060")
    hiVia(f "APP_RETURN_HI_4L_USB_ATTACH_N_1_V2" "GND" list(47.0 13.45) "L28_VIA030_C060")
    hiVia(f "APP_RETURN_VBUS_LEFT_V" "GND" list(36.077 8.725) "L28_VIA030_C060")
    hiHSEIsolationChallengeGraph("D:/001DIY/005lib/01AIEDA/learning/examples/lessonHI_38_50_20261021/logs/USB_aux_4L_b014" list(45.45 28.85) "L2" list(list(42.2 39.8) list(44.2 39.8) list(47.8 33.5)))
    t)
   progn(
    axlDBControl('drcEnable t)
    fprintf(f "HI_UNWIND_DRC_RESTORED=%L\n" axlDBControl('drcEnable))))
  unless(axlDBControl('drcEnable) error("Final DRC must be enabled\n"))
  hiFinalize(f "D:/001DIY/005lib/01AIEDA/learning/examples/lessonHI_38_50_20261021/logs/USB_aux_4L_b014" "D:/001DIY/005lib/01AIEDA/learning/examples/lessonHI_38_50_20261021/native/HI_4L_USB_aux_4L_b014.brd" "D:/001DIY/005lib/01AIEDA/learning/examples/lessonHI_38_50_20261021/library" list(list("R11.1" "Q2.3" t) list("R7.2" "Q1.1" t) list("R8.1" "Q1.1" t) list("R9.2" "Q1.3" t) list("R10.2" "Q2.1" t) list("R18.1" "J4.3" t) list("R3.2" "U1.23" t) list("R4.2" "U1.23" t) list("J2.A5" "R3.1" t) list("J2.B5" "R4.1" t) list("J2.A4_B9" "C10.1" t) list("J2.B4_A9" "C10.1" t) list("R7.1" "C10.1" t) list("CC_R3_GND_V" "U1.23" t) list("APP_RETURN_HI_4L_USB_ATTACH_N_1_V1" "U1.23" t) list("APP_RETURN_HI_4L_USB_ATTACH_N_1_V2" "U1.23" t) list("APP_RETURN_VBUS_LEFT_V" "U1.23" t)))
  t))
