procedure(hiFinalize(f out board lib proofs)
 let((storedCount)
  unless(equal(axlShapeDynamicUpdate(nil t) 0) error("Actual final construction fill failed\n"))
  axlDBRefreshId(nil)
  fprintf(f "HI_PRE_PROOF_UNSAVED_MEMORY_DIAGNOSTIC_SNAPSHOT_NOT_RELEASED\n") drain(f)
  gSnapshot(out lib) hiNetworkInventory(out) hiExtraRead(out) hiShapeBoundaryRead(out) hiRouteRoles(out) hiUSBMaskRead(out) hiBranchAudit(out) hiMechanicalPinRead(out)
  foreach(p proofs hiProof(f car(p) cadr(p) caddr(p)))
  storedCount=length(axlDBGetDesign()->drcs)
  fprintf(f "HI_PENDING_SCOPE_NO_WHOLE_BOARD_DRC_REQUEST time=%L rawStoredDRCCountForensicOnly=%d nativeDRC=UNRECOMPUTED physicalModes=%L spacingModes=%L electricalModes=%L online=%L\n" getCurrentTime() storedCount axlCNSPhysicalModeGet('all) axlCNSSpacingModeGet('all) axlCNSEcsetModeGet('all) axlDBControl('drcEnable)) drain(f)
  unless(axlSaveDesign(?design board ?noMru t ?noConfirm t) error("Cannot SaveAs new DRC_PENDING task candidate\n"))
  fprintf(f "HI_BATCH_COMPLETED status=GEOMETRY_AND_NATIVE_CONNECTIVITY_PROOFS_SAVED_DRC_UNRECOMPUTED_PENDING rawStoredDRCs=%d board=%L\n" storedCount board)
  close(f)
  gSnapshot(out lib)
  hiNetworkInventory(out)
  hiExtraRead(out)
  hiShapeBoundaryRead(out)
  hiRouteRoles(out)
  hiUSBMaskRead(out)
  hiBranchAudit(out)
  hiMechanicalPinRead(out)
  t))
