procedure(l28Mechanical(out)
 let((f gf d layer obj poly)
 f=outfile(strcat(out "/mechanical_roots.txt"))
 gf=outfile(strcat(out "/mechanical_direct.tsv"))
 d=axlDBGetDesign()
 fprintf(f "designOutline=%L\nkeepinPlace=%L\nkeepinRoute=%L\n" if(d->designOutline then t else nil) if(d->keepinPlace then t else nil) if(d->keepinRoute then t else nil))
 fprintf(gf "layer\tbbox\tfilled\tprops\tvertices\n")
 foreach(layer list("BOARD GEOMETRY/DESIGN_OUTLINE" "ROUTE KEEPIN/ALL" "PACKAGE KEEPIN/ALL" "ROUTE KEEPOUT/ALL" "PACKAGE KEEPOUT/ALL" "PACKAGE KEEPOUT/TOP" "PACKAGE KEEPOUT/BOTTOM" "PACKAGE GEOMETRY/PLACE_BOUND_TOP")
  foreach(obj axlDBGetShapes(layer)
   poly=car(axlPolyFromDB(obj))
   fprintf(gf "%L\t%L\t%L\t%L\t%L\n" layer obj->bBox obj->fill axlDBGetProperties(obj nil) if(poly then poly->vertices else nil))))
 fprintf(f "L28_MECHANICAL_DIRECT COMPLETE\n") close(f) close(gf) t))
