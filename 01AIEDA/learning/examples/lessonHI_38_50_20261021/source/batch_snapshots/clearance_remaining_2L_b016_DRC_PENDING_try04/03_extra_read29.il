procedure(f29ExtraRead(out)
 let((f rf gf lf des o p poly seen)
  f=outfile(strcat(out "/direct_geometry.tsv"))
  rf=outfile(strcat(out "/route_geometry.tsv"))
  gf=outfile(strcat(out "/group_members.tsv"))
  lf=outfile(strcat(out "/stackup_full.tsv"))
  des=axlDBGetDesign()
  fprintf(f "role\tlayer\tbbox\tvertices\n")
  foreach(x list(list("DESIGN_OUTLINE" des->designOutline) list("ROUTE_KEEPIN" des->keepinRoute) list("PACKAGE_KEEPIN" des->keepinPlace))
   o=cadr(x)
   when(o
    poly=car(axlPolyFromDB(o))
    fprintf(f "%s\t%L\t%L\t%L\n" car(x) o->layer o->bBox if(poly then poly->vertices else nil))))
  foreach(l list("ROUTE KEEPOUT/ALL" "PACKAGE KEEPOUT/ALL" "PACKAGE KEEPOUT/TOP" "PACKAGE KEEPOUT/BOTTOM")
   foreach(o axlDBGetShapes(l)
    poly=car(axlPolyFromDB(o))
    fprintf(f "KEEPOUT\t%L\t%L\t%L\n" o->layer o->bBox if(poly then poly->vertices else nil))))
  fprintf(gf "group\tgroupType\tphysical\tspacing\telectrical\tmember\tmemberType\n")
  foreach(o append(des->netclass des->diffpair)
   foreach(p o->groupMembers
    fprintf(gf "%s\t%L\t%L\t%L\t%L\t%L\t%L\n" o->name o->type if(equal(o->type "NETCLASS") then o->physical else nil) if(equal(o->type "NETCLASS") then o->spacing else nil) if(equal(o->type "NETCLASS") then o->electrical else nil) p->name p->objType)))
  fprintf(lf "position\tname\ttype\tfunction\tmaterial\tthickness\tdk\tloss\tconductor\tnegative\tmfg\n")
  foreach(x axlXSectionGet(nil 'all)
   fprintf(lf "%L\t%L\t%L\t%L\t%L\t%L\t%L\t%L\t%L\t%L\t%L\n" x->position x->name x->layerType x->layerFunction x->material x->thickness x->dielectricConst x->lossTangent x->conductor x->negativeArtwork x->mfg))
  fprintf(rf "kind\tnet\tlayer\tstartEnd\twidth\tattributes\n")
  seen=nil
  foreach(o axlExtractMap("C:/Program0/Cadence/SPB172/share/pcb/text/views/fgeo_bv.txt" nil)
   unless(member(o seen)
    seen=cons(o seen)
    when(member(o->objType list("path" "line" "cline" "arc" "clineseg" "lineSeg"))
     fprintf(rf "%L\t%L\t%L\t%L\t%L\t%L\n" o->objType if(o->net then o->net->name else nil) o->layer o->startEnd o->width o->??))))
  foreach(o list(f rf gf lf) close(o))
  t))
