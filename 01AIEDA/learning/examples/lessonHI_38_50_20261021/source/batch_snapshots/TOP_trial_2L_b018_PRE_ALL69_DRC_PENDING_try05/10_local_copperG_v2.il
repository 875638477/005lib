procedure(gPin(ref number)
 let((p)
  p=car(setof(x gComponent(ref)->symbol->pins equal(x->number number)))
  unless(p error("Missing physical pin %s.%s\n" ref number)) p))
procedure(gRouteNative(net points widths layer f label)
 let((path i result)
  unless(length(points)==length(widths)+1 error("Path width sequence mismatch\n"))
  path=axlPathStart(list(car(points)) car(widths))
  i=0
  foreach(point cdr(points)
   unless(axlPathLine(path nth(i widths) point) error("Path segment failed\n"))
   i=i+1)
  result=axlDBCreatePath(path layer net)
  fprintf(f "LOCAL_ROUTE\t%s\t%L\t%L\t%L\t%L\t%L\n" label net layer points widths result)
  unless(result error("Local route creation failed\n")) result))
procedure(gReference(layer f)
 let((poly shape dyn ret)
  poly=car(axlPolyFromDB(axlDBGetDesign()->keepinRoute))
  unless(poly error("No actual route keepin polygon\n"))
  shape=car(axlDBCreateShape(poly t layer "GND" nil))
  unless(shape error("Native real GND copper creation failed\n"))
  dyn=axlShapeChangeDynamicType(shape t t)
  unless(dyn error("Dynamic ground conversion failed\n"))
  ret=axlShapeDynamicUpdate(dyn t)
  fprintf(f "REFERENCE_DYNAMIC layer=%L result=%L OOD=%L boundary=%L\n" layer ret axlDBDynamicShapes(nil) dyn->??)
  unless(equal(ret 0) && equal(axlDBDynamicShapes(nil) 0) error("Ground copper fill not current\n"))
  unless(axlDBGetShapes(layer) error("No generated real ETCH copper\n"))
  foreach(shape axlDBGetShapes(layer)
   fprintf(f "REAL_REFERENCE_COPPER\t%L\n" shape->??))
  dyn))
procedure(gConnectedObjects(start)
 let((todo seen obj neighbors)
  todo=list(start) seen=nil
  while(todo
   obj=car(todo) todo=cdr(todo)
   unless(member(obj seen)
    seen=cons(obj seen)
    neighbors=axlDBGetConnect(obj t)
    when(member(obj->objType list("path" "cline" "line" "arc"))
     when(listp(car(neighbors)) neighbors=append(car(neighbors) cadr(neighbors))))
    foreach(n neighbors unless(member(n seen) todo=cons(n todo)))))
  seen))
procedure(gConnectivityProof(f ref pin targetRef targetPin expectedLayer)
 let((start target graph plane)
  start=gPin(ref pin) target=gPin(targetRef targetPin)
  graph=gConnectedObjects(start)
  fprintf(f "NATIVE_CONNECTIVITY\t%L\t%L\t%L\t%L\ttargetReached=%L\tobjects=%d\n" ref pin targetRef targetPin if(member(target graph) then t else nil) length(graph))
  unless(member(target graph) error("Actual copper graph does not connect expected pins\n"))
  when(expectedLayer
   plane=setof(x graph equal(x->objType "shape") && equal(x->layer expectedLayer) && x->fill && x->net && equal(x->net->name "GND"))
   fprintf(f "NATIVE_REFERENCE_REACHED\t%L\t%L\t%L\tcount=%d\n" ref pin expectedLayer length(plane))
   unless(plane error("Ground pin does not reach actual filled ETCH reference copper\n")))
  t))
