procedure(hiReferenceParams()
 list(axlDBControl('dynamicFillMode) axlGetParam("shapeDynamic")->?? axlGetParam("shapeStatic")->??))
procedure(hiDeferReference(f id layer polygon)
 let((target record voids vertices)
  unless(hiDeferredReferences hiReferenceParamsBefore=hiReferenceParams())
  target=hiUniqueExactShape("GND" layer polygon t) voids=nil
  foreach(v target->voids
   vertices=car(axlPolyFromDB(v))->vertices
   when(exists(p vertices abs(cadr(p))>0.0000001) error("Curved permanent void not supported by this exact construction defer\n"))
   voids=append(voids list(mapcar('car vertices))))
  record=list(id layer polygon voids axlDBGetProperties(target) target->priority target->fill target->shapeIsBoundary)
  fprintf(f "HI_REFERENCE_DEFER_BEFORE definition=%L fullOriginalAttributes=%L globalShapeParameters=%L\n" record target->?? hiReferenceParamsBefore) drain(f)
  unless(member(layer list("TOP" "BOTTOM")) error("This defer is authorized only on actual2LTOP/BOTTOM appdynamic boundaries\n"))
  unless(axlDeleteObject(target) error("Cannot remove exact authorized appdynamic boundary\n"))
  axlDBRefreshId(nil) hiDeferredReferences=append(hiDeferredReferences list(record))
  fprintf(f "HI_REFERENCE_DEFER_COMPLETE id=%L staticQuietAndManualCopperNotSelected=t\n" id) t))
procedure(hiRestoreReference(f id)
 let((record target ret actualVoids)
  record=assoc(id hiDeferredReferences)
  unless(record error("No original reference definition for restore\n"))
  hiShape(f id "GND" cadr(record) caddr(record) t nil)
  foreach(poly nth(3 record) hiVoid(f id poly))
  target=hiUniqueExactShape("GND" cadr(record) caddr(record) t)
  when(nth(4 record) unless(axlDBAddProp(list(target) nth(4 record)) error("Cannot restore original shape-specific properties\n")))
  ret=axlShapeRaisePriority(target)
  unless(numberp(ret) error("Cannot preserve reference relative priority construction order\n"))
  actualVoids=nil
  foreach(v target->voids actualVoids=append(actualVoids list(mapcar('car car(axlPolyFromDB(v))->vertices))))
  unless(length(actualVoids)==length(nth(3 record)) error("Restored permanent void count differs\n"))
  foreach(poly nth(3 record) unless(length(setof(v target->voids hiPolygonMatches(v poly)))==1 error("Restored permanent void polygon differs\n")))
  unless(equal(axlDBGetProperties(target) nth(4 record)) && equal(target->fill nth(6 record)) && equal(target->shapeIsBoundary nth(7 record)) error("Restored dynamic definition/overrides differ\n"))
  fprintf(f "HI_REFERENCE_RESTORED id=%L polygonAndVoidsExact=t propertiesExact=t oldPriority=%L actualPriority=%L relativePriorityOnlyOfficial=t actual=%L\n" id nth(5 record) target->priority target->??) t))
procedure(hiVerifyReferences(f)
 let((a b ta tb params)
  unless(equal(axlShapeDynamicUpdate(nil t) 0) error("Restored reference fill failed\n"))
  axlDBRefreshId(nil) params=hiReferenceParams()
  fprintf(f "HI_REFERENCE_GLOBAL_PARAMETERS_AFTER=%L exactEqualBefore=%L\n" params equal(params hiReferenceParamsBefore))
  unless(equal(params hiReferenceParamsBefore) error("Global dynamic/static/thermal parameter record changed during defer/restore\n"))
  foreach(a hiDeferredReferences
   ta=hiUniqueExactShape("GND" cadr(a) caddr(a) t)
   foreach(b hiDeferredReferences
    when(equal(cadr(a) cadr(b)) && nth(5 a)<nth(5 b)
     tb=hiUniqueExactShape("GND" cadr(b) caddr(b) t)
     unless(ta->priority<tb->priority error("Relative reference voiding priority order changed\n")))))
  fprintf(f "HI_REFERENCE_DEFINITIONS_FILL_RELATIVE_PRIORITY_VERIFIED count=%d\n" length(hiDeferredReferences)) t))
procedure(hiScopedSpacingFieldChallenge(out name layer field netName normal strict)
 let((f net before count strictCount hits result allValues)
  f=outfile(strcat(out "/strict_" name "_" symbolToString(field) ".txt"))
  net=axlDBFindByName('net netName) before=axlCNSGetSpacing(name layer nil)
  unless(before && abs(axlCNSGetSpacing(name layer field)-normal)<0.00001 error("Unexpected strict-challenge normal field baseline\n"))
  count=axlDRCItem(nil net)
  fprintf(f "SCOPED_NORMAL_BEFORE net=%L result=%L field=%L cset=%L actual=%L\n" netName count field name axlCNSGetSpacing(name layer field)) drain(f)
  unless(numberp(count) && count==0 error("Normal scoped network has unresolved violations before strict challenge\n"))
  unwindProtect(progn(
   unless(axlCNSSetSpacing(name layer field strict) error("Cannot tighten precise spacing field\n"))
   strictCount=axlDRCItem(nil net) hits=nil
   f29DumpDRC(f "PRECISE_STRICT_ALL_NATIVE")
   foreach(d axlDBGetDesign()->drcs
    when(equal(d->objType "drc") && equal(d->name "Line to SMD Pin Spacing") && d->expected && abs(atof(d->expected)-strict)<0.00001 && d->actual && atof(d->actual)<strict && atof(d->actual)>=normal-0.0001
     hits=cons(d hits) fprintf(f "STRICT_ACTUAL_NATIVE_VIOLATION=%L\n" d->??)
     foreach(obj d->violations fprintf(f "STRICT_ACTUAL_VIOLATING_PHYSICAL_OBJECT=%L\n" obj->??))))
   fprintf(f "SCOPED_STRICT_RESULT count=%L requested=%L hitCount=%d\n" strictCount strict length(hits))
   unless(numberp(strictCount) && strictCount>0 && hits error("Precise stricter spacing did not produce actual violation\n")) t)
   progn(
    axlCNSSetSpacing(name layer field normal)
    result=axlDRCItem(nil net) allValues=axlCNSGetSpacing(name layer nil)
    fprintf(f "SCOPED_FIELD_RESTORED result=%L field=%L actual=%L allLayerFieldsExactlyRestored=%L\n" result field axlCNSGetSpacing(name layer field) equal(before allValues))
    unless(numberp(result) && result==0 && equal(before allValues) error("Precise field challenge did not restore normal pass/all fields\n"))))
  fprintf(f "SCOPED_STRICT_FIELD_CHALLENGE_COMPLETE_NOT_WHOLE_BOARD_DRC\n") close(f) t))
procedure(hiScopedChangedNetworks(out names)
 let((f net count)
  f=outfile(strcat(out "/changed_nets_scoped_drc.txt"))
  foreach(name names
   net=axlDBFindByName('net name)
   fprintf(f "SCOPED_CHANGED_NETWORK_BEGIN net=%L time=%L\n" name getCurrentTime()) drain(f)
   count=axlDRCItem(nil net)
   fprintf(f "SCOPED_CHANGED_NETWORK_RESULT net=%L result=%L time=%L\n" name count getCurrentTime()) drain(f)
   unless(numberp(count) && count==0
    f29DumpDRC(f "CHANGED_NET_SCOPED_FAILED") close(f) error("Changed network scoped DRC failed %s result=%L\n" name count)))
  fprintf(f "SCOPED_CHANGED_NETWORKS_COMPLETE count=%d NOT_WHOLE_BOARD_CHECK=t\n" length(names)) close(f) t))
