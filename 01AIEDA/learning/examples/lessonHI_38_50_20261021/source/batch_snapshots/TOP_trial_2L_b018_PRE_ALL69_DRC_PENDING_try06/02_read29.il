procedure(f29Read(out)
 let((f nf pf sf ef cf vf des nc props seen o ps pad lay n)
  deBoardRead(out)
  f=outfile(strcat(out "/constraint_summary.txt"))
  nf=outfile(strcat(out "/net_rules.tsv"))
  pf=outfile(strcat(out "/physical_csets.tsv"))
  sf=outfile(strcat(out "/spacing_csets.tsv"))
  ef=outfile(strcat(out "/electrical_csets.tsv"))
  cf=outfile(strcat(out "/class_table.tsv"))
  vf=outfile(strcat(out "/vias.tsv"))
  des=axlDBGetDesign()
  fprintf(nf "net\tphysicalClass\tspacingClass\telectricalClass\tprops\tinheritedMaxVia\tinheritedPhase\tinheritedUncoupled\n")
  foreach(net des->nets
   fprintf(nf "%s\t%L\t%L\t%L\t%L\t%L\t%L\t%L\n" net->name
    if(axlNetClassGet(net 'physical t) then axlNetClassGet(net 'physical t)->name else nil)
    if(axlNetClassGet(net 'spacing t) then axlNetClassGet(net 'spacing t)->name else nil)
    if(axlNetClassGet(net 'electrical t) then axlNetClassGet(net 'electrical t)->name else nil)
    axlDBGetProperties(net) axlNetEcsetValueGet(net 'Maximum_Via_Count)
    axlNetEcsetValueGet(net 'Differential_Pair_Phase_Tolerance)
    axlNetEcsetValueGet(net 'Differential_Pair_Max_Uncoupled_Length)))
  fprintf(pf "cset\tlayer\tvalues\n")
  foreach(c axlCnsList('physical) foreach(l axlSubclassRoute()
   fprintf(pf "%s\t%s\t%L\n" c l axlCNSGetPhysical(c l nil))))
  fprintf(sf "cset\tlayer\tvalues\n")
  foreach(c axlCnsList('spacing) foreach(l axlSubclassRoute()
   fprintf(sf "%s\t%s\t%L\n" c l axlCNSGetSpacing(c l nil))))
  fprintf(ef "cset\tvalues\n")
  foreach(c axlCnsList('electrical) fprintf(ef "%s\t%L\n" c axlCNSEcsetValueGet(c 'all t)))
  foreach(c des->netclass fprintf(f "CLASS\t%s\t%L\t%L\n" c->name c->?? axlDBGetProperties(c)))
  foreach(p des->diffpair fprintf(f "PAIR\t%s\t%L\t%L\n" p->name p->?? axlDBGetProperties(p)))
  fprintf(cf "object\tproperties\tattributes\n")
  foreach(c axlCnsClassTableFind('netclass)
   fprintf(cf "%L\t%L\t%L\n" c axlDBGetProperties(c) c->??))
  fprintf(vf "name\tx\ty\tnet\tusage\tdrill\tlayer\tfigure\tbbox\n")
  seen=nil
  foreach(o axlExtractMap("C:/Program0/Cadence/SPB172/share/pcb/text/views/fgeo_bv.txt" nil)
   when(equal(o->objType "via") && !member(o seen)
    seen=cons(o seen) ps=o->definition
    foreach(lay list("ETCH/TOP" "ETCH/L2" "ETCH/L3" "ETCH/BOTTOM")
     pad=axlDBGetPad(o lay "REGULAR")
     fprintf(vf "%L\t%L\t%L\t%L\t%L\t%L\t%L\t%L\t%L\n" o->name car(o->xy) cadr(o->xy) if(o->net then o->net->name else nil) ps->usage ps->drillDiameter lay if(pad then pad->figureName else nil) if(pad then pad->bBox else nil)))))
  fprintf(f "PHYSICAL_MODES\t%L\nSPACING_MODES\t%L\nELECTRICAL_MODES\t%L\n" axlCNSPhysicalModeGet('all) axlCNSSpacingModeGet('all) axlCNSEcsetModeGet('all))
  f29DumpDRC(f "READBACK")
  fprintf(f "READBACK_COMPLETE\n")
  foreach(o list(f nf pf sf ef cf vf) close(o)) t))
