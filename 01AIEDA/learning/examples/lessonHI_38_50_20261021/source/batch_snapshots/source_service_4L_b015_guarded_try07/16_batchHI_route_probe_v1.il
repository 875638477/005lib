procedure(hiRoute(f id net layer points widths)
 let((ret actualPoints actualWidths paths rr previous index)
  actualPoints=points actualWidths=widths
  when(equal(id "RIGHT_BOOT_DIRECT_TOP")
   fprintf(f "HI_BOOT_CONSTRUCTION_PHYSICAL_ANCHORS U1_44=%L R28_1=%L R28_2=%L\n" gPin("U1" "44")->?? gPin("R28" "1")->?? gPin("R28" "2")->??)
   actualPoints=reverse(points) actualWidths=reverse(widths)
   fprintf(f "HI_BOOT_REVERSE_CONSTRUCTION_SAME_GEOMETRY requestedPoints=%L actualConstructionPoints=%L fromPhysicalR28Pin=t\n" points actualPoints) drain(f))
  if(equal(id "RIGHT_BOOT_DIRECT_TOP") then
   paths=nil previous=car(actualPoints) index=0
   fprintf(f "HI_BOOT_PHYSICAL_NATIVE_NET_NAMES MCU=%L R28=%L targetLogicalNet=%L\n" gPin("U1" "44")->net->name gPin("R28" "1")->net->name axlDBFindByName('net net)) drain(f)
   foreach(p cdr(actualPoints)
    fprintf(f "HI_BOOT_SINGLE_SEGMENT index=%d start=%L end=%L width=%L\n" index previous p nth(index actualWidths)) drain(f)
    when(index==1
     gSnapshot(hiDiagnosticOutput hiDiagnosticLibrary)
     hiRouteRoles(hiDiagnosticOutput)
     hiShapeBoundaryRead(hiDiagnosticOutput)
     fprintf(f "HI_BOOT_FAILED_STAGE_PROVISIONAL_GEOMETRY_DUMP_COMPLETE_NOT_CHECKPOINT\n") drain(f))
    rr=gRouteNative(net list(previous p) list(nth(index actualWidths)) strcat("ETCH/" layer) f sprintf(nil "%s_SEGMENT_%d" id index))
    paths=append(paths car(rr)) previous=p index=index+1)
   ret=list(paths nil)
  else ret=gRouteNative(net actualPoints actualWidths strcat("ETCH/" layer) f id))
  foreach(o car(ret)
   fprintf(f "HI_CREATED_ROUTE_NATIVE_NET id=%L expected=%L object=%L actualNet=%L layer=%L\n" id net o if(o->net then o->net->name else nil) o->layer))
  hiReg(id "route" car(ret))
  ret))
