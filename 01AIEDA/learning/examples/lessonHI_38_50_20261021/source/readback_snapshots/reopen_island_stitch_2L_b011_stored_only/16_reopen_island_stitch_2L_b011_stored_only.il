procedure(hiGroundPointCheckReadOnly(f id xy topConnected bottomConnected)
 let((graph shapes expected actual)
  graph=gConnectedObjects(gPin("U1" "23"))
  foreach(layer list("TOP" "BOTTOM")
   expected=if(equal(layer "TOP") then topConnected else bottomConnected)
   shapes=setof(s axlDBGetShapes(strcat("ETCH/" layer)) s->fill && s->net && equal(s->net->name "GND") && !s->shapeIsBoundary && axlGeoPointInShape(xy s t))
   unless(length(shapes)==1 error("Ground stitch point must be inside exactly one actual filled GND shape on each layer, layer=%L shapes=%L\n" layer shapes))
   unless(car(shapes)->shapeBoundary error("Ground stitch point must be in application dynamic copper, not static quiet island\n"))
   actual=if(member(car(shapes) graph) then t else nil)
   fprintf(f "HI_GROUND_POINT_CHECK id=%L layer=%L xy=%L bbox=%L globalPin=U1.23 expectedConnected=%L actualConnected=%L shapeAttrs=%L\n" id layer xy car(shapes)->bBox expected actual car(shapes)->??)
   unless(equal(expected actual) error("Application ground shape connectivity does not match intended stitch pre/post condition\n")))
  t))

procedure(hiStoredReadback()
 let((f)
 f=outfile("D:/001DIY/005lib/01AIEDA/learning/examples/lessonHI_38_50_20261021/logs/reopen_island_stitch_2L_b011_stored_only/hi_reopen_endpoint_proofs.txt")
 hiRegistry=nil hiNodeDefinitions=list(list("V_HI_GPIO_ISLAND_STITCH" "GND" "TOP" list(37.4 27.4) "via"))
 hiBindExistingVia(f "V_HI_GPIO_ISLAND_STITCH" "GND" list(37.4 27.4) "L28_VIA030_C060")
 hiGroundPointCheckReadOnly(f "FRESH_STITCH_ACTUAL_SHAPE" list(37.4 27.4) t t)
 hiProof(f "V_HI_GPIO_ISLAND_STITCH" "U1.23" t)
 fprintf(f "HI_REOPEN_ALL_ENDPOINTS_COMPLETE_STORED_STATE_ONLY_NO_DRC_RECOMPUTE\n") close(f)
 f=outfile("D:/001DIY/005lib/01AIEDA/learning/examples/lessonHI_38_50_20261021/logs/reopen_island_stitch_2L_b011_stored_only/hi_readback_scope.txt")
 fprintf(f "READBACK_SCOPE=FRESH_STORED_STATE_GEOMETRY_CONNECTIVITY_ONLY\nFULL_DRC_RECOMPUTE=NOT_REQUESTED_IN_THIS_READBACK\nFINAL_WHOLE_BOARD_DRC_PENDING=t\nDRC_ENABLE=%L\nSTORED_DRC_COUNT=%d\nPHYSICAL_MODES=%L\nSPACING_MODES=%L\nELECTRICAL_MODES=%L\n" axlDBControl('drcEnable) length(axlDBGetDesign()->drcs) axlCNSPhysicalModeGet('all) axlCNSSpacingModeGet('all) axlCNSEcsetModeGet('all)) close(f) t))
