procedure(hiReadbackProofs()
 let((f)
  f=outfile("D:/001DIY/005lib/01AIEDA/learning/examples/lessonHI_38_50_20261021/logs/reopen_postcritical_2L_b010/hi_reopen_endpoint_proofs.txt")
  hiRegistry=nil
  unwindProtect(progn(
   axlDBControl('drcEnable nil)
  hiNodeDefinitions=list(list("STAR_BOTTOM_FEED_DIAGONAL" "V3V3" "BOTTOM" list(30.7 32.0) "point") list("STAR_PERIPH_TAP_TOP" "V3V3" "TOP" list(37.0 24.0) "point") list("STAR_DIAG_GROUND_RETURN" "GND" "TOP" list(35.75 24.75) "point") list("V_HI_STAR_GND_EAST" "GND" "TOP" list(38.0 25.27) "via") list("V3_PERIPH_SOUTH" "V3V3" "TOP" list(33.3 22.5) "point") list("V3_PERIPH_EAST" "V3V3" "TOP" list(78.2 2.4) "point") list("V3_PERIPH_NORTH" "V3V3" "TOP" list(78.2 58.2) "point") list("V3_PERIPH_WEST_J6" "V3V3" "TOP" list(1.8 58.2) "point") list("V3_J4" "V3V3" "TOP" list(78.2 28.81) "point") list("V3_J5" "V3V3" "TOP" list(78.2 42.81) "point") list("V3_J11" "V3V3" "TOP" list(9.11 58.2) "point") list("V3_J12" "V3V3" "TOP" list(31.11 58.2) "point") list("V3_J13" "V3V3" "TOP" list(53.11 58.2) "point") list("V3_CAN_MAIN" "V3V3" "TOP" list(60.5 1.0) "point") list("V3_SPI_NSS_PULLUP" "V3V3" "TOP" list(33.3 22.5) "point") list("V3_USB_AUX_R9" "V3V3" "TOP" list(59.8 13.46) "point") list("V3_USB_AUX_Q2" "V3V3" "TOP" list(56.2 13.46) "point") list("V3_USB_ATTACH_PULLUP" "V3V3" "TOP" list(49.9 12.2282) "point") list("V3_SWD_VTREF" "V3V3" "TOP" list(48.6016 17.2) "point") list("V3_UART_IDLE" "V3V3" "TOP" list(74.0 28.81) "point") list("V3_BOOT_SERVICE" "V3V3" "TOP" list(74.0 28.81) "point") list("V3_I2C_PULLUPS" "V3V3" "TOP" list(78.2 47.0) "point") list("V3_RESET_PULLUP" "V3V3" "TOP" list(31.11 55.0) "point") list("GPIO_GPIO_PC13_TOP" "GPIO_PC13" "TOP" list(42.25 31.25) "point") list("GPIO_GPIO_PC13_VIA" "GPIO_PC13" "TOP" list(42.0 28.9) "via") list("GPIO_GPIO_PC14_TOP" "GPIO_PC14" "TOP" list(41.75 31.25) "point") list("GPIO_GPIO_PC14_VIA" "GPIO_PC14" "TOP" list(41.0 27.8) "via") list("GPIO_GPIO_PC15_TOP" "GPIO_PC15" "TOP" list(41.25 31.25) "point") list("GPIO_GPIO_PC15_VIA" "GPIO_PC15" "TOP" list(40.3 28.9) "via") list("GPIO_GPIO_PC13_BOTTOM_START" "GPIO_PC13" "BOTTOM" list(42.0 28.9) "point") list("GPIO_GPIO_PC14_BOTTOM_START" "GPIO_PC14" "BOTTOM" list(41.0 27.8) "point") list("GPIO_GPIO_PC15_BOTTOM_START" "GPIO_PC15" "BOTTOM" list(40.3 28.9) "point") list("GPIO_RETURN_EAST" "GND" "TOP" list(42.0 27.9) "via") list("GPIO_RETURN_WEST" "GND" "TOP" list(39.8 27.3) "via") list("GPIO_PC14_EAST_EXIT" "GPIO_PC14" "TOP" list(45.6 25.2) "via") list("GPIO_RETURN_EAST_EXIT" "GND" "TOP" list(46.95 24.9) "via") list("CAN_H_U5_TERM" "CAN_H" "TOP" list(69.588 14.73) "point") list("CAN_H_TERM_J3" "CAN_H" "TOP" list(71.5 14.75) "point") list("CAN_L_U5_TERM" "CAN_L" "TOP" list(69.588 13.46) "point") list("CAN_L_TERM_J3" "CAN_L" "TOP" list(71.5 11.702) "point") list("CAN_TX_IDLE_BRANCH" "CAN_TXD" "TOP" list(64.0 16.0) "point") list("CAN_VCC_LOCAL" "V3V3" "TOP" list(59.8 13.46) "point") list("CAN_GND_LOCAL" "GND" "TOP" list(64.0 14.73) "point") list("CAN_GND_VIA_A" "GND" "TOP" list(62.7 14.73) "point") list("V_HI_CAN_GND_A" "GND" "TOP" list(62.6 14.73) "via") list("CAN_GND_VIA_B" "GND" "TOP" list(60.8 15.0348) "point") list("V_HI_CAN_GND_B" "GND" "TOP" list(60.8 15.8348) "via") list("CAN_TX_PULLUP_V3" "V3V3" "TOP" list(59.8 13.46) "point") list("NSS_SOURCE_SERIES" "PA4_SPI_NSS" "TOP" list(35.75 29.25) "point") list("NSS_PULLUP_INWARD" "PA4_SPI_NSS" "TOP" list(35.75 29.25) "point") list("NSS_PULLUP_INNER_VIA" "PA4_SPI_NSS" "TOP" list(39.0 26.2) "via") list("NSS_PULLUP_WEST_VIA" "PA4_SPI_NSS" "TOP" list(32.2 22.0) "via") list("NSS_PULLUP_BOTTOM" "PA4_SPI_NSS" "BOTTOM" list(39.0 26.2) "point") list("NSS_PULLUP_RESISTOR" "PA4_SPI_NSS" "TOP" list(32.2 22.0) "point") list("NSS_PULLUP_GND_RETURN" "GND" "TOP" list(31.0 21.6) "via") list("SPI_SOURCE_SCK_PRECISE" "PA5_SPI_SCK" "TOP" list(35.75 28.75) "point") list("SPI_SOURCE_MISO_PRECISE" "PA6_SPI_MISO" "TOP" list(35.75 28.25) "point") list("SPI_SOURCE_MOSI_PRECISE" "PA7_SPI_MOSI" "TOP" list(35.75 27.75) "point") list("V_HI_V3_SOURCE" "V3V3" "BOTTOM" list(30.7 32.0) "via") list("V_HI_V3_STAR" "V3V3" "BOTTOM" list(37.0 24.0) "via") list("V3_PERIPH_SOURCE_TOP" "V3V3" "TOP" list(33.3 22.5) "point") list("V3_PERIM_EAST_LOW" "V3V3" "TOP" list(78.2 2.4) "point") list("V3_PERIM_EAST_HIGH" "V3V3" "TOP" list(78.2 58.2) "point") list("V3_PERIM_WEST_HIGH" "V3V3" "TOP" list(1.8 58.2) "point"))
  hiBindExistingShapeByBBox(f "HI_GPIO_TOP_REF_1_1" "GND" "TOP" list(list(35.8 27.0) list(42.4 31.9)))
  hiBindExistingShapeByBBox(f "HI_GPIO_TOP_REF_2_1" "GND" "TOP" list(list(39.2 24.6) list(47.5 28.4)))
  hiBindExistingVia(f "V_HI_STAR_GND_EAST" "GND" list(38.0 25.27) "L28_VIA030_C060")
  hiBindExistingVia(f "GPIO_GPIO_PC13_VIA" "GPIO_PC13" list(42.0 28.9) "L28_VIA030_C060")
  hiBindExistingVia(f "GPIO_GPIO_PC14_VIA" "GPIO_PC14" list(41.0 27.8) "L28_VIA030_C060")
  hiBindExistingVia(f "GPIO_GPIO_PC15_VIA" "GPIO_PC15" list(40.3 28.9) "L28_VIA030_C060")
  hiBindExistingVia(f "GPIO_RETURN_EAST" "GND" list(42.0 27.9) "L28_VIA030_C060")
  hiBindExistingVia(f "GPIO_RETURN_WEST" "GND" list(39.8 27.3) "L28_VIA030_C060")
  hiBindExistingVia(f "GPIO_PC14_EAST_EXIT" "GPIO_PC14" list(45.6 25.2) "L28_VIA030_C060")
  hiBindExistingVia(f "GPIO_RETURN_EAST_EXIT" "GND" list(46.95 24.9) "L28_VIA030_C060")
  hiBindExistingVia(f "V_HI_CAN_GND_A" "GND" list(62.6 14.73) "L28_VIA030_C060")
  hiBindExistingVia(f "V_HI_CAN_GND_B" "GND" list(60.8 15.8348) "L28_VIA030_C060")
  hiBindExistingVia(f "NSS_PULLUP_INNER_VIA" "PA4_SPI_NSS" list(39.0 26.2) "L28_VIA030_C060")
  hiBindExistingVia(f "NSS_PULLUP_WEST_VIA" "PA4_SPI_NSS" list(32.2 22.0) "L28_VIA030_C060")
  hiBindExistingVia(f "NSS_PULLUP_GND_RETURN" "GND" list(31.0 21.6) "L28_VIA030_C060")
  hiProof(f "V_HI_V3_SOURCE" "V_HI_V3_STAR" t)
  hiProof(f "V_HI_V3_STAR" "V3_PERIPH_SOURCE_TOP" t)
  hiProof(f "U1.23" "V_HI_STAR_GND_EAST" t)
  hiProof(f "V3_PERIPH_SOURCE_TOP" "V3_PERIM_EAST_LOW" t)
  hiProof(f "V3_PERIM_EAST_LOW" "V3_PERIM_EAST_HIGH" t)
  hiProof(f "V3_PERIM_EAST_HIGH" "V3_PERIM_WEST_HIGH" t)
  hiProof(f "V3_PERIM_WEST_HIGH" "J6.1" t)
  hiProof(f "V3_PERIPH_EAST" "J4.1" t)
  hiProof(f "V3_PERIPH_EAST" "J5.1" t)
  hiProof(f "V3_PERIPH_NORTH" "J11.1" t)
  hiProof(f "V3_PERIPH_NORTH" "J12.1" t)
  hiProof(f "V3_PERIPH_NORTH" "J13.1" t)
  hiProof(f "V3_PERIPH_SOUTH" "C12.1" t)
  hiProof(f "V3_PERIPH_SOURCE_TOP" "R25.1" t)
  hiProof(f "C12.1" "R9.1" t)
  hiProof(f "V3_USB_AUX_R9" "Q2.2" t)
  hiProof(f "V3_USB_AUX_Q2" "R10.1" t)
  hiProof(f "R10.1" "J9.1" t)
  hiProof(f "J4.1" "R18.2" t)
  hiProof(f "J4.1" "R30.1" t)
  hiProof(f "V3_PERIPH_EAST" "R19.1" t)
  hiProof(f "J12.1" "R27.1" t)
  hiProof(f "U1.2" "GPIO_GPIO_PC13_VIA" t)
  hiProof(f "U1.3" "GPIO_GPIO_PC14_VIA" t)
  hiProof(f "U1.4" "GPIO_GPIO_PC15_VIA" t)
  hiProof(f "GPIO_GPIO_PC14_VIA" "GPIO_PC14_EAST_EXIT" t)
  hiProof(f "U5.7" "R15.1" t)
  hiProof(f "R15.1" "J3.1" t)
  hiProof(f "U5.6" "R15.2" t)
  hiProof(f "R15.2" "J3.2" t)
  hiProof(f "U5.1" "R14.2" t)
  hiProof(f "C12.1" "U5.3" t)
  hiProof(f "U5.2" "C12.2" t)
  hiProof(f "CAN_GND_LOCAL" "V_HI_CAN_GND_A" t)
  hiProof(f "CAN_GND_LOCAL" "V_HI_CAN_GND_B" t)
  hiProof(f "C12.1" "R14.1" t)
  hiProof(f "NSS_PULLUP_INNER_VIA" "NSS_PULLUP_WEST_VIA" t)
  hiProof(f "U1.15" "R21.1" t)
  hiProof(f "U1.16" "R24.1" t)
  hiProof(f "U1.17" "R22.1" t)
  hiProof(f "U1.14" "R23.1" t)
  hiProof(f "U1.14" "R25.2" t)
  hiProof(f "U1.15" "R21.1" t)
  hiProof(f "U1.16" "R24.1" t)
  hiProof(f "U1.17" "R22.1" t)
  hiProof(f "C9.1" "J4.1" t)
  hiProof(f "C9.1" "J5.1" t)
  hiProof(f "C9.1" "J6.1" t)
  hiProof(f "C9.1" "J9.1" t)
  hiProof(f "C9.1" "J11.1" t)
  hiProof(f "C9.1" "J12.1" t)
  hiProof(f "C9.1" "J13.1" t)
  hiProof(f "C9.1" "R25.1" t)
  hiProof(f "C9.1" "R19.1" t)
  hiProof(f "C9.1" "R20.1" t)
  hiProof(f "C9.1" "R27.1" t)
  hiProof(f "C9.1" "R30.1" t)
  hiProof(f "C9.1" "R9.1" t)
  hiProof(f "C9.1" "R10.1" t)
  hiProof(f "C9.1" "R18.2" t)
  hiProof(f "C9.1" "Q2.2" t)
  hiProof(f "C9.1" "C12.1" t)
  hiProof(f "U1.23" "V_HI_STAR_GND_EAST" t)
  hiProof(f "U1.23" "U1.47" t)
  hiProof(f "C9.1" "U1.24" t)
  hiProof(f "C9.1" "U1.36" t)
  hiProof(f "C9.1" "U1.48" t)
  hiProof(f "C9.1" "U1.1" t)
  hiHSEIsolationChallengeGraph("D:/001DIY/005lib/01AIEDA/learning/examples/lessonHI_38_50_20261021/logs/reopen_postcritical_2L_b010" list(45.45 28.85) "BOTTOM" list(list(42.2 39.8) list(44.2 39.8) list(47.8 33.5)))
  t) progn(axlDBControl('drcEnable t) fprintf(f "HI_READBACK_UNWIND_DRC_RESTORED=%L\n" axlDBControl('drcEnable))))
  fprintf(f "HI_REOPEN_ALL_ENDPOINTS_COMPLETE\n") close(f) t))
