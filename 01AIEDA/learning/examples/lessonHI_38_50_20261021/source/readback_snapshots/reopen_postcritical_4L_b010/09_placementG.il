procedure(gComponent(ref)
 let((c)
  c=car(setof(x axlDBGetDesign()->components equal(x->name ref)))
  unless(c error("Missing logical component %s\n" ref)) c))
procedure(gSnapshot(out lib)
 let((pf gf df tf obj pin pad poly d)
  gInventory(out lib)
  pf=outfile(strcat(out "/g_actual_pins.tsv"))
  gf=outfile(strcat(out "/g_actual_geometry.tsv"))
  df=outfile(strcat(out "/g_drc_details.txt"))
  tf=outfile(strcat(out "/board_instance_texts.tsv"))
  fprintf(tf "refdes\tpackage\tlayer\ttext\txy\trotation\tmirrored\tjustify\ttextBlock\tbbox\tattrs\n")
  fprintf(pf "refdes\tpackage\tanchor\trotation\tmirrored\tpin\txy\tnet\tpadstack\tpadRotation\tmechanical\tlayer\tfigure\tpadbbox\n")
  fprintf(gf "refdes\tpackage\ttype\tlayer\tbbox\tprops\tvertices\n")
  foreach(obj axlDBGetDesign()->symbols
   foreach(pin obj->pins
    foreach(layer append(mapcar(lambda((x) strcat("ETCH/" x)) axlSubclassRoute()) list("PIN/SOLDERMASK_TOP" "PIN/SOLDERMASK_BOTTOM"))
     pad=axlDBGetPad(pin layer "REGULAR")
     fprintf(pf "%L\t%L\t%L\t%L\t%L\t%L\t%L\t%L\t%L\t%L\t%L\t%L\t%L\t%L\n" obj->refdes obj->name obj->xy obj->rotation obj->isMirrored pin->number pin->xy if(pin->net then pin->net->name else nil) pin->name pin->rotation pin->isMech layer if(pad then pad->figureName else nil) if(pad then pad->bBox else nil))))
   foreach(shape obj->children
    when(equal(shape->objType "text")
     fprintf(tf "%L\t%L\t%L\t%L\t%L\t%L\t%L\t%L\t%L\t%L\t%L\n" obj->refdes obj->name shape->layer shape->text shape->xy shape->rotation shape->isMirrored shape->justify shape->textBlock shape->bBox shape->??))
    when(member(shape->objType list("shape" "path" "line" "circle" "text"))
     poly=if(equal(shape->objType "shape") then car(axlPolyFromDB(shape)) else nil)
     fprintf(gf "%L\t%L\t%L\t%L\t%L\t%L\t%L\n" obj->refdes obj->name shape->objType shape->layer shape->bBox axlDBGetProperties(shape) if(poly then poly->vertices else nil)))))
  gCopperRead(out)
  f29DumpDRC(df "G_SNAPSHOT")
  foreach(drc axlDBGetDesign()->drcs
   foreach(v drc->violations
    fprintf(df "VIOLATION_OBJECT\tref=%L\t%L\n" if(equal(v->objType "pin") then v->parent->refdes else nil) v->??)))
  fprintf(df "G_SNAPSHOT_COMPLETE\n")
  foreach(f list(pf gf df tf) close(f)) t))
procedure(gPlace(plan board out lib expectedLayers)
 let((f c sym result count beforeMechanical beforeJ2)
  f=outfile(strcat(out "/placement.txt"))
  axlSetVariable("psmpath" list(lib))
  axlSetVariable("padpath" list(lib))
  unless(equal(axlSubclassRoute() expectedLayers) error("Wrong source layer variant\n"))
  beforeMechanical=mapcar(lambda((s) list(s->name s->xy s->rotation)) setof(s axlDBGetDesign()->symbols equal(s->type "MECHANICAL")))
  beforeJ2=gComponent("J2")->symbol
  fprintf(f "START source=%L layers=%L components=%d J2=%L mechanical=%L\n" axlCurrentDesign() axlSubclassRoute() length(axlDBGetDesign()->components) list(beforeJ2->xy beforeJ2->rotation beforeJ2->isMirrored) beforeMechanical)
  unless(length(plan)==80 error("Placement plan must include exactly80 logical components\n"))
  count=0
  foreach(row plan
   c=gComponent(car(row))
   if(c->symbol then
    sym=c->symbol
    unless(equal(sym->xy list(cadr(row) caddr(row))) && equal(sym->rotation cadddr(row)) error("Existing placed symbol differs from protected plan\n"))
    fprintf(f "PRESERVED\t%L\t%L\t%L\n" c->name sym->xy sym->rotation)
   else
    result=axlDBCreateSymbol(c->name list(cadr(row) caddr(row)) nil cadddr(row))
    unless(result error("Place failed %s\n" c->name))
    sym=car(result)
    fprintf(f "PLACED\t%L\t%L\t%L\t%L\n" c->name sym->xy sym->rotation cadr(result)))
   count=count+1)
  axlDBRefreshId(nil)
  fprintf(f "POST_REFRESH logicalPlaced=%d symbols=%d\n" length(setof(c axlDBGetDesign()->components c->symbol)) length(axlDBGetDesign()->symbols))
  unless(length(setof(c axlDBGetDesign()->components c->symbol))==80 error("Incomplete placement\n"))
  unless(equal(beforeMechanical mapcar(lambda((s) list(s->name s->xy s->rotation)) setof(s axlDBGetDesign()->symbols equal(s->type "MECHANICAL")))) error("Protected mechanical moved\n"))
  axlDRCUpdate(t)
  f29DumpDRC(f "PLACEMENT")
  unless(axlSaveDesign(?design board ?noMru t ?noConfirm t) error("G placement save failed\n"))
  fprintf(f "G_PLACEMENT_COMPLETE count=%d\n" count)
  close(f)
  gSnapshot(out lib)
  t))

procedure(gCopperRead(out)
 let((f poly shape)
  f=outfile(strcat(out "/g_copper_shapes.tsv"))
  fprintf(f "layer\tnet\tfilled\tboundary\tgenerated\tfillOOD\tbbox\tarea\tvertices\tholes\n")
  foreach(shape axlDBGetShapes("ETCH")
   foreach(poly axlPolyFromDB(shape)
    fprintf(f "%L\t%L\t%L\t%L\t%L\t%L\t%L\t%L\t%L\t%L\n" shape->layer if(shape->net then shape->net->name else nil) shape->fill shape->shapeIsBoundary if(shape->shapeBoundary then t else nil) shape->fillOOD shape->bBox poly->area poly->vertices mapcar(lambda((h) h->vertices) poly->holes))))
  close(f) t))
