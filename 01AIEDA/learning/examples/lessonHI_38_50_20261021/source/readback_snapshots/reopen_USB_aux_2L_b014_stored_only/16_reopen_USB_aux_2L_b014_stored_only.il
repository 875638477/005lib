procedure(hiGroundPointCheckReadOnly(f id xy topConnected bottomConnected)
 let((graph shapes expected actual)
  graph=gConnectedObjects(gPin("U1" "23"))
  foreach(layer list("TOP" "BOTTOM")
   expected=if(equal(layer "TOP") then topConnected else bottomConnected)
   shapes=setof(s axlDBGetShapes(strcat("ETCH/" layer)) s->fill && s->net && equal(s->net->name "GND") && !s->shapeIsBoundary && axlGeoPointInShape(xy s t))
   unless(length(shapes)==1 error("Ground stitch point must be inside exactly one actual filled GND shape on each layer, layer=%L shapes=%L\n" layer shapes))
   unless(car(shapes)->shapeBoundary error("Ground stitch point must be in application dynamic copper, not static quiet island\n"))
   actual=if(member(car(shapes) graph) then t else nil)
   fprintf(f "HI_GROUND_POINT_CHECK id=%L layer=%L xy=%L bbox=%L globalPin=U1.23 expectedConnected=%L actualConnected=%L shapeAttrs=%L\n" id layer xy car(shapes)->bBox expected actual car(shapes)->??)
   unless(equal(expected actual) error("Application ground shape connectivity does not match intended stitch pre/post condition\n")))
  t))

; Instrument exact unchanged all-on-plus-batch DRC request and result.
procedure(hiStoredReadback()
 let((f)
 f=outfile("D:/001DIY/005lib/01AIEDA/learning/examples/lessonHI_38_50_20261021/logs/reopen_USB_aux_2L_b014_stored_only/hi_reopen_endpoint_proofs.txt")
 hiRegistry=nil hiNodeDefinitions=list(list("HI_2L_USB_PULLUP_SRC_1_R1" "USB_PULLUP_SRC" "TOP" list(42.8748 14.6) "point") list("HI_2L_VBUS_GATE_1_R1" "VBUS_GATE" "TOP" list(50.6764 7.0) "point") list("HI_2L_VBUS_GATE_2_R1" "VBUS_GATE" "TOP" list(56.2 9.1016) "point") list("HI_2L_VBUS_PRESENT_N_1_R1" "VBUS_PRESENT_N" "TOP" list(56.2 14.6764) "point") list("HI_2L_UART_RX_1_R1" "UART_RX" "TOP" list(68.1016 25.0) "point") list("HI_2L_USB_ATTACH_N_1_V1" "USB_ATTACH_N" "TOP" list(50.8 16.3) "via") list("HI_2L_USB_ATTACH_N_1_V2" "USB_ATTACH_N" "TOP" list(47.95 13.45) "via") list("HI_2L_USB_ATTACH_N_1_R1" "USB_ATTACH_N" "TOP" list(50.1764 17.2) "point") list("HI_2L_USB_ATTACH_N_1_R2" "USB_ATTACH_N" "BOTTOM" list(50.8 16.3) "point") list("HI_2L_USB_ATTACH_N_1_R3" "USB_ATTACH_N" "TOP" list(47.95 13.45) "point") list("CC1_ENTRY" "USB_CC1" "TOP" list(38.75 7.355) "point") list("CC2_ENTRY" "USB_CC2" "TOP" list(41.75 7.355) "point") list("CC_R3_GND" "GND" "TOP" list(35.0 11.6764) "point") list("CC_R3_GND_V" "GND" "TOP" list(36.1 11.6764) "via") list("CC_R4_GND" "GND" "TOP" list(45.5 11.6764) "point") list("VBUS_LEFT_ESCAPE" "USB_VBUS" "TOP" list(37.6 7.355) "point") list("VBUS_LEFT_V" "USB_VBUS" "TOP" list(36.9 9.2) "via") list("USB_RETURN_LEFT_NEW" "GND" "TOP" list(38.3 5.6) "via") list("USB_RETURN_RIGHT_NEW" "GND" "TOP" list(41.0 4.7) "via") list("VBUS_LEFT_LOW_ROUTE" "USB_VBUS" "BOTTOM" list(36.9 9.2) "point") list("VBUS_RIGHT_UNDER_HOUSING" "USB_VBUS" "TOP" list(42.4 7.355) "point") list("VBUS_RIGHT_V" "USB_VBUS" "TOP" list(42.0 3.7) "via") list("VBUS_RIGHT_TO_CLAMP" "USB_VBUS" "BOTTOM" list(42.0 3.7) "point") list("VBUS_SENSE_V" "USB_VBUS" "TOP" list(47.8 7.0) "via") list("VBUS_SENSE_TOP" "USB_VBUS" "TOP" list(47.8 7.0) "point") list("VBUS_SENSE_BOTTOM" "USB_VBUS" "BOTTOM" list(43.8 9.2016) "point") list("APP_RETURN_HI_2L_USB_ATTACH_N_1_V1" "GND" "TOP" list(51.411 17.028) "via") list("APP_RETURN_HI_2L_USB_ATTACH_N_1_V2" "GND" "TOP" list(47.0 13.45) "via") list("APP_RETURN_VBUS_LEFT_V" "GND" "TOP" list(36.077 8.725) "via") list("APP_RETURN_VBUS_SENSE_V" "GND" "TOP" list(46.907 6.675) "via"))
 hiBindExistingVia(f "HI_2L_USB_ATTACH_N_1_V1" "USB_ATTACH_N" list(50.8 16.3) "L28_VIA030_C060")
 hiBindExistingVia(f "HI_2L_USB_ATTACH_N_1_V2" "USB_ATTACH_N" list(47.95 13.45) "L28_VIA030_C060")
 hiBindExistingVia(f "CC_R3_GND_V" "GND" list(36.1 11.6764) "L28_VIA030_C060")
 hiBindExistingVia(f "VBUS_LEFT_V" "USB_VBUS" list(36.9 9.2) "L28_VIA030_C060")
 hiBindExistingVia(f "USB_RETURN_LEFT_NEW" "GND" list(38.3 5.6) "L28_VIA030_C060")
 hiBindExistingVia(f "USB_RETURN_RIGHT_NEW" "GND" list(41.0 4.7) "L28_VIA030_C060")
 hiBindExistingVia(f "VBUS_RIGHT_V" "USB_VBUS" list(42.0 3.7) "L28_VIA030_C060")
 hiBindExistingVia(f "VBUS_SENSE_V" "USB_VBUS" list(47.8 7.0) "L28_VIA030_C060")
 hiBindExistingVia(f "APP_RETURN_HI_2L_USB_ATTACH_N_1_V1" "GND" list(51.411 17.028) "L28_VIA030_C060")
 hiBindExistingVia(f "APP_RETURN_HI_2L_USB_ATTACH_N_1_V2" "GND" list(47.0 13.45) "L28_VIA030_C060")
 hiBindExistingVia(f "APP_RETURN_VBUS_LEFT_V" "GND" list(36.077 8.725) "L28_VIA030_C060")
 hiBindExistingVia(f "APP_RETURN_VBUS_SENSE_V" "GND" list(46.907 6.675) "L28_VIA030_C060")
 hiProof(f "R11.1" "Q2.3" t)
 hiProof(f "R7.2" "Q1.1" t)
 hiProof(f "R8.1" "Q1.1" t)
 hiProof(f "R9.2" "Q1.3" t)
 hiProof(f "R10.2" "Q2.1" t)
 hiProof(f "R18.1" "J4.3" t)
 hiProof(f "R3.2" "U1.23" t)
 hiProof(f "R4.2" "U1.23" t)
 hiProof(f "J2.A5" "R3.1" t)
 hiProof(f "J2.B5" "R4.1" t)
 hiProof(f "J2.A4_B9" "C10.1" t)
 hiProof(f "J2.B4_A9" "C10.1" t)
 hiProof(f "R7.1" "C10.1" t)
 hiProof(f "CC_R3_GND_V" "U1.23" t)
 hiProof(f "USB_RETURN_LEFT_NEW" "U1.23" t)
 hiProof(f "USB_RETURN_RIGHT_NEW" "U1.23" t)
 hiProof(f "APP_RETURN_HI_2L_USB_ATTACH_N_1_V1" "U1.23" t)
 hiProof(f "APP_RETURN_HI_2L_USB_ATTACH_N_1_V2" "U1.23" t)
 hiProof(f "APP_RETURN_VBUS_LEFT_V" "U1.23" t)
 hiProof(f "APP_RETURN_VBUS_SENSE_V" "U1.23" t)
 fprintf(f "HI_REOPEN_ALL_ENDPOINTS_COMPLETE_STORED_STATE_ONLY_NO_DRC_RECOMPUTE\n") close(f)
 f=outfile("D:/001DIY/005lib/01AIEDA/learning/examples/lessonHI_38_50_20261021/logs/reopen_USB_aux_2L_b014_stored_only/hi_readback_scope.txt")
 fprintf(f "READBACK_SCOPE=FRESH_STORED_STATE_GEOMETRY_CONNECTIVITY_ONLY\nFULL_DRC_RECOMPUTE=NOT_REQUESTED_IN_THIS_READBACK\nFINAL_WHOLE_BOARD_DRC_PENDING=t\nHSE_NEGATIVE_NOT_REPEATED_HERE_BUILD_EVIDENCE_REMAINS\nDRC_ENABLE=%L\nSTORED_DRC_COUNT=%d\nPHYSICAL_MODES=%L\nSPACING_MODES=%L\nELECTRICAL_MODES=%L\n" axlDBControl('drcEnable) length(axlDBGetDesign()->drcs) axlCNSPhysicalModeGet('all) axlCNSSpacingModeGet('all) axlCNSEcsetModeGet('all)) close(f) t))
