procedure(hiHSEReplacePilot()
 let((f mark before)
 f=outfile("D:/001DIY/005lib/01AIEDA/learning/examples/lessonHI_38_50_20261021/logs/HSE_replacement_rollback_4L_01/hi_hse_replace_rollback.txt")
 hiRegistry=nil
 before=hiUniqueExactShape("GND" "L2" list(list(45.1 28.5) list(45.8 28.5) list(45.8 31.25) list(45.1 31.95) list(45.3 31.95) list(45.3 33.2) list(47.5 33.2) list(47.5 39.4) list(37.2 39.4) list(37.2 36.8) list(40.0 36.8) list(40.0 32.8) list(40.6 32.8) list(40.6 31.95) list(44.4 31.95) list(45.1 31.25)) nil)
 fprintf(f "BEFORE quietShape=%L oldStemPoint=%L newStemPoint=%L storedDRCs=%d\n" before axlGeoPointInShape(list(45.45 29.5) before t) axlGeoPointInShape(list(46.35 30.5) before t) length(axlDBGetDesign()->drcs))
 mark=axlDBTransactionStart()
 unwindProtect(progn(axlDBControl('drcEnable nil)
 hiReplaceExactShape(f "PILOT_NEW_QUIET" "GND" "L2" list(list(45.1 28.5) list(45.8 28.5) list(45.8 31.25) list(45.1 31.95) list(45.3 31.95) list(45.3 33.2) list(47.5 33.2) list(47.5 39.4) list(37.2 39.4) list(37.2 36.8) list(40.0 36.8) list(40.0 32.8) list(40.6 32.8) list(40.6 31.95) list(44.4 31.95) list(45.1 31.25)) list(list(46.0 29.3) list(46.7 29.3) list(46.7 31.25) list(46.2 31.75) list(46.2 33.2) list(47.5 33.2) list(47.5 39.4) list(37.2 39.4) list(37.2 36.8) list(40.0 36.8) list(40.0 32.8) list(40.6 32.8) list(40.6 31.95) list(45.3 31.95) list(46.0 31.25)) nil nil)
 hiReplaceExactVoid(f "PILOT_APP_L2" "GND" "L2" list(list(0.5 0.5) list(79.5 59.5)) list(list(44.75 28.15) list(46.15 28.15) list(46.15 31.4) list(45.65 31.9) list(45.65 32.85) list(47.85 32.85) list(47.85 39.75) list(36.85 39.75) list(36.85 36.45) list(39.65 36.45) list(39.65 32.45) list(40.25 32.45) list(40.25 31.6) list(44.25 31.6) list(44.75 31.1)) list(list(45.65 28.95) list(45.65 31.10502525316942) list(45.15502525316942 31.599999999999998) list(40.25 31.599999999999998) list(40.25 32.449999999999996) list(39.65 32.449999999999996) list(39.65 36.449999999999996) list(36.85 36.449999999999996) list(36.85 39.75) list(47.85 39.75) list(47.85 32.85) list(46.550000000000004 32.85) list(46.550000000000004 31.89497474683058) list(47.050000000000004 31.39497474683058) list(47.050000000000004 28.95)))
 hiReplaceExactVoid(f "PILOT_APP_L3" "GND" "L3" list(list(0.5 0.5) list(79.5 59.5)) list(list(44.75 28.15) list(46.15 28.15) list(46.15 31.4) list(45.65 31.9) list(45.65 32.85) list(47.85 32.85) list(47.85 39.75) list(36.85 39.75) list(36.85 36.45) list(39.65 36.45) list(39.65 32.45) list(40.25 32.45) list(40.25 31.6) list(44.25 31.6) list(44.75 31.1)) list(list(45.65 28.95) list(45.65 31.10502525316942) list(45.15502525316942 31.599999999999998) list(40.25 31.599999999999998) list(40.25 32.449999999999996) list(39.65 32.449999999999996) list(39.65 36.449999999999996) list(36.85 36.449999999999996) list(36.85 39.75) list(47.85 39.75) list(47.85 32.85) list(46.550000000000004 32.85) list(46.550000000000004 31.89497474683058) list(47.050000000000004 31.39497474683058) list(47.050000000000004 28.95)))
 axlShapeDynamicUpdate(nil t) axlDBRefreshId(nil)
 before=hiUniqueExactShape("GND" "L2" list(list(46.0 29.3) list(46.7 29.3) list(46.7 31.25) list(46.2 31.75) list(46.2 33.2) list(47.5 33.2) list(47.5 39.4) list(37.2 39.4) list(37.2 36.8) list(40.0 36.8) list(40.0 32.8) list(40.6 32.8) list(40.6 31.95) list(45.3 31.95) list(46.0 31.25)) nil)
 fprintf(f "REPLACED oldStemPoint=%L newStemPoint=%L noFullDRCRequested=t\n" axlGeoPointInShape(list(45.45 29.5) before t) axlGeoPointInShape(list(46.35 30.5) before t))
 unless(!axlGeoPointInShape(list(45.45 29.5) before t) && axlGeoPointInShape(list(46.35 30.5) before t) error("New quiet stem not actually replaced\n"))
 t) progn(unless(axlDBTransactionRollback(mark) error("Reference replacement rollback failed\n")) axlDBControl('drcEnable t)))
 before=hiUniqueExactShape("GND" "L2" list(list(45.1 28.5) list(45.8 28.5) list(45.8 31.25) list(45.1 31.95) list(45.3 31.95) list(45.3 33.2) list(47.5 33.2) list(47.5 39.4) list(37.2 39.4) list(37.2 36.8) list(40.0 36.8) list(40.0 32.8) list(40.6 32.8) list(40.6 31.95) list(44.4 31.95) list(45.1 31.25)) nil)
 unless(member(gPin("U1" "47") gConnectedObjects(gPin("C22" "2"))) error("Original quiet bridge graph did not restore\n"))
 fprintf(f "HSE_REFERENCE_REPLACE_ROLLBACK_COMPLETE_NO_SAVE_NO_FULL_DRC_REQUEST oldShapeRestored=%L C22toVSS47Restored=t drcEnable=%L\n" before axlDBControl('drcEnable)) close(f) t))
