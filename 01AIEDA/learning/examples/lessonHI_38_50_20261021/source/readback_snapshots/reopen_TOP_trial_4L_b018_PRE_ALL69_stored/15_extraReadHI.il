procedure(hiBindExistingVia(f id net xy padstack)
 let((v found)
  found=nil
  foreach(v axlExtractMap("C:/Program0/Cadence/SPB172/share/pcb/text/views/fgeo_bv.txt" nil)
   when(equal(v->objType "via") && equal(v->xy xy) && equal(v->net->name net) && equal(upperCase(v->name) upperCase(padstack))
    unless(member(v found) found=cons(v found))))
  unless(length(found)==1 error("Via alias not uniquely found %s\n" id))
  hiReg(id "via" car(found))
  fprintf(f "HI_EXISTING_VIA_ALIAS %L %L %L\n" id xy car(found))
  car(found)))
procedure(hiExtraRead(out)
 let((f r s poly tbl)
  f=outfile(strcat(out "/hi_rules_context.tsv"))
  fprintf(f "kind\tname\tdata1\tdata2\tdata3\tdata4\n")
  foreach(r axlDBGetDesign()->netclass
   fprintf(f "CLASS\t%L\t%L\t%L\t%L\t%L\n" r->name axlDBGetProperties(r) r->physical r->spacing r->electrical))
  foreach(r axlDBGetDesign()->region
   foreach(s r->groupMembers
    poly=car(axlPolyFromDB(s))
    fprintf(f "REGION\t%L\t%L\t%L\t%L\t%L\n" r->name s->layer s->bBox if(poly then poly->vertices else nil) s->??)))
  foreach(tbl axlCnsClassTableFind('netclass)
   fprintf(f "TABLE\t%L\t%L\t%L\t%L\t%L\n" if(tbl->region then tbl->region->name else nil)
    if(tbl->netclass1 then tbl->netclass1->name else nil)
    if(tbl->netclass2 then tbl->netclass2->name else nil)
    list(tbl->physical tbl->spacing tbl->sameNet) tbl->??))
  fprintf(f "HI_RULES_CONTEXT_COMPLETE\n") close(f) t))
procedure(hiChallengeNeck(out name normal strict)
 let((f)
  f=outfile(strcat(out "/hi_local_neck_challenge.txt"))
  unless(equal(axlCNSGetPhysical(name "TOP" 'necklength_max) normal) error("Unexpected starting local neck rule\n"))
  unless(axlCNSSetPhysical(name nil 'necklength_max sprintf(nil "%L MM" strict)) error("Cannot tighten local neck\n"))
  axlDRCUpdate(t) f29DumpDRC(f "HI_STRICT_LOCAL_NECK")
  unless(length(axlDBGetDesign()->drcs)>0 error("Local neck actual DRC did not trigger\n"))
  unless(axlCNSSetPhysical(name nil 'necklength_max sprintf(nil "%L MM" normal)) error("Cannot restore local neck\n"))
  axlDRCUpdate(t) f29DumpDRC(f "HI_LOCAL_NECK_RESTORED")
  unless(length(axlDBGetDesign()->drcs)==0 error("Local neck restoration failed\n"))
  fprintf(f "HI_NECK_CHALLENGE_COMPLETE_NO_SAVE\n") close(f) t))
