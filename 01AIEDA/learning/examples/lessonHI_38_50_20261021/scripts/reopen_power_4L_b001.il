procedure(hiPowerReopenProof()
 let((f)
  f=outfile("D:/001DIY/005lib/01AIEDA/learning/examples/lessonHI_38_50_20261021/logs/reopen_power_4L_b001/hi_reopen_endpoint_proofs.txt")
  hiRegistry=nil
  hiBindExistingVia(f "V_HI_C3_A" "GND" list(23.2 18.0) "L28_VIA030_C060")
  hiBindExistingVia(f "V_HI_C3_B" "GND" list(23.2 18.8) "L28_VIA030_C060")
  hiBindExistingVia(f "V_HI_U2_A" "GND" list(23.7 22.55) "L28_VIA030_C060")
  hiBindExistingVia(f "V_HI_U2_B" "GND" list(23.7 23.35) "L28_VIA030_C060")
  hiBindExistingVia(f "V_HI_C2_A" "GND" list(22.152 14.25) "L28_VIA030_C060")
  hiBindExistingVia(f "V_HI_C2_B" "GND" list(22.152 13.45) "L28_VIA030_C060")
  hiProof(f "U2.3" "C3.1" t)
  hiProof(f "C2.1" "C3.1" t)
  hiProof(f "U2.2" "L1.1" t)
  hiProof(f "U2.6" "C4.1" t)
  hiProof(f "C4.2" "L1.1" t)
  hiProof(f "C3.2" "V_HI_C3_B" t)
  hiProof(f "U2.1" "V_HI_U2_B" t)
  hiProof(f "C2.2" "V_HI_C2_B" t)
  fprintf(f "HI_REOPEN_ALL_ENDPOINTS_COMPLETE\n") close(f) t))
