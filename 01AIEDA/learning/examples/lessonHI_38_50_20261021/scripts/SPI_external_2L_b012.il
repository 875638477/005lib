procedure(hiBatchProgram()
 let((f)
  f=outfile("D:/001DIY/005lib/01AIEDA/learning/examples/lessonHI_38_50_20261021/logs/SPI_external_2L_b012/hi_batch_execution.txt")
  fprintf(f "HI_BATCH_DRC_BEFORE=%L\n" axlDBControl('drcEnable))
  unwindProtect(
   progn(
    axlDBControl('drcEnable nil)
    fprintf(f "HI_ASSEMBLY_ONLINE_DRC_TEMPORARILY_DISABLED=%L\n" axlDBControl('drcEnable))
    hiRegistry=nil
    hiNodeDefinitions=list(list("SPI_PREFILTER_ROW_SHIFT" "V3V3" "TOP" list(29.8 30.95) "point") list("SPI_SCK_EAST" "SPI_SCK" "TOP" list(30.8 29.95) "via") list("SPI_SCK_WEST" "SPI_SCK" "TOP" list(21.85 29.95) "via") list("SPI_SCK_EAST_TOP" "SPI_SCK" "TOP" list(32.0252 31.0) "point") list("SPI_SCK_BOTTOM_BRIDGE" "SPI_SCK" "BOTTOM" list(30.8 29.95) "point") list("SPI_SCK_WEST_TOP" "SPI_SCK" "TOP" list(21.85 29.95) "point") list("SPI_MOSI_EAST" "SPI_MOSI" "TOP" list(31.65 27.8) "via") list("SPI_MOSI_WEST" "SPI_MOSI" "TOP" list(14.0 29.3) "via") list("SPI_MOSI_EAST_TOP" "SPI_MOSI" "TOP" list(32.0252 27.0) "point") list("SPI_MOSI_BOTTOM_BRIDGE" "SPI_MOSI" "BOTTOM" list(31.65 27.8) "point") list("SPI_MOSI_WEST_TOP" "SPI_MOSI" "TOP" list(14.0 29.3) "point") list("SPI_MISO_EAST" "SPI_MISO" "TOP" list(31.65 29.77) "via") list("SPI_MISO_WEST" "SPI_MISO" "TOP" list(20.5 30.8) "via") list("SPI_MISO_EAST_TOP" "SPI_MISO" "TOP" list(32.0252 29.0) "point") list("SPI_MISO_BOTTOM_BRIDGE" "SPI_MISO" "BOTTOM" list(31.65 29.77) "point") list("SPI_MISO_WEST_TOP" "SPI_MISO" "TOP" list(20.5 30.8) "point") list("SPI_NSS_EAST" "SPI_NSS" "TOP" list(29.6 32.46) "via") list("SPI_NSS_WEST" "SPI_NSS" "TOP" list(20.3 32.4) "via") list("SPI_NSS_EAST_TOP" "SPI_NSS" "TOP" list(31.2236 33.02) "point") list("SPI_NSS_BOTTOM_BRIDGE" "SPI_NSS" "BOTTOM" list(29.6 32.46) "point") list("SPI_NSS_WEST_TOP" "SPI_NSS" "TOP" list(20.3 32.4) "point") list("SPI_RETURN_SCK_E" "GND" "TOP" list(30.9 29.1) "via") list("SPI_RETURN_SCK_W" "GND" "TOP" list(20.5 29.32) "via") list("SPI_RETURN_MOSI_E" "GND" "TOP" list(32.8 25.3) "via") list("SPI_RETURN_MOSI_W" "GND" "TOP" list(14.0 30.6) "via") list("SPI_RETURN_MISO_E" "GND" "TOP" list(32.85 28.1) "via") list("SPI_RETURN_GUARD_E" "GND" "TOP" list(27.1 31.55) "via") list("SPI_RETURN_GUARD_W" "GND" "TOP" list(21.0 31.55) "via") list("SPI_RETURN_NSS_E" "GND" "TOP" list(29.0 33.2) "via") list("SPI_RETURN_NSS_W" "GND" "TOP" list(20.8 33.75) "via") list("SPI_GUARD_CLOCK_MOSI" "GND" "BOTTOM" list(28.6 29.0) "point") list("SPI_GUARD_MISO_NSS" "GND" "BOTTOM" list(29.9 31.55) "point"))
    hiDeleteSegment(f "SPI_RIP_PREFILTER_0" "V3V3" "TOP" list(list(29.8 30.95) list(28.4 32.35)) 0.6)
    hiDeleteSegment(f "SPI_RIP_PREFILTER_1" "V3V3" "TOP" list(list(28.4 32.35) list(22.0 32.35)) 0.6)
    hiDeleteSegment(f "SPI_RIP_PREFILTER_2" "V3V3" "TOP" list(list(22.0 32.35) list(22.0 37.0)) 0.6)
    hiRoute(f "SPI_PREFILTER_ROW_SHIFT" "V3V3" "TOP" list(list(29.8 30.95) list(28.2 32.55) list(22.0 32.55) list(22.0 37.0)) list(0.6 0.6 0.6))
    hiVia(f "SPI_SCK_EAST" "SPI_SCK" list(30.8 29.95) "L28_VIA030_C060")
    hiVia(f "SPI_SCK_WEST" "SPI_SCK" list(21.85 29.95) "L28_VIA030_C060")
    hiRoute(f "SPI_SCK_EAST_TOP" "SPI_SCK" "TOP" list(list(32.0252 31.0) list(31.85 31.0) list(30.8 29.95)) list(0.2 0.2))
    hiRoute(f "SPI_SCK_BOTTOM_BRIDGE" "SPI_SCK" "BOTTOM" list(list(30.8 29.95) list(21.85 29.95)) list(0.2))
    hiRoute(f "SPI_SCK_WEST_TOP" "SPI_SCK" "TOP" list(list(21.85 29.95) list(21.65 30.15) list(16.2 30.15) list(14.59 28.54) list(7.0 28.54)) list(0.2 0.2 0.2 0.2))
    hiVia(f "SPI_MOSI_EAST" "SPI_MOSI" list(31.65 27.8) "L28_VIA030_C060")
    hiVia(f "SPI_MOSI_WEST" "SPI_MOSI" list(14.0 29.3) "L28_VIA030_C060")
    hiRoute(f "SPI_MOSI_EAST_TOP" "SPI_MOSI" "TOP" list(list(32.0252 27.0) list(32.0252 27.4248) list(31.65 27.8)) list(0.2 0.2))
    hiRoute(f "SPI_MOSI_BOTTOM_BRIDGE" "SPI_MOSI" "BOTTOM" list(list(31.65 27.8) list(31.15 28.3) list(26.6 28.3) list(26.4 28.5) list(14.8 28.5) list(14.0 29.3)) list(0.2 0.2 0.2 0.2 0.2))
    hiRoute(f "SPI_MOSI_WEST_TOP" "SPI_MOSI" "TOP" list(list(14.0 29.3) list(12.22 31.08) list(7.0 31.08)) list(0.2 0.2))
    hiVia(f "SPI_MISO_EAST" "SPI_MISO" list(31.65 29.77) "L28_VIA030_C060")
    hiVia(f "SPI_MISO_WEST" "SPI_MISO" list(20.5 30.8) "L28_VIA030_C060")
    hiRoute(f "SPI_MISO_EAST_TOP" "SPI_MISO" "TOP" list(list(32.0252 29.0) list(31.65 29.3752) list(31.65 29.77)) list(0.2 0.2))
    hiRoute(f "SPI_MISO_BOTTOM_BRIDGE" "SPI_MISO" "BOTTOM" list(list(31.65 29.77) list(31.42 30.0) list(31.42 30.23) list(30.85 30.8) list(20.5 30.8)) list(0.2 0.2 0.2 0.2))
    hiRoute(f "SPI_MISO_WEST_TOP" "SPI_MISO" "TOP" list(list(20.5 30.8) list(17.68 33.62) list(7.0 33.62)) list(0.2 0.2))
    hiVia(f "SPI_NSS_EAST" "SPI_NSS" list(29.6 32.46) "L28_VIA030_C060")
    hiVia(f "SPI_NSS_WEST" "SPI_NSS" list(20.3 32.4) "L28_VIA030_C060")
    hiRoute(f "SPI_NSS_EAST_TOP" "SPI_NSS" "TOP" list(list(31.2236 33.02) list(30.16 33.02) list(29.6 32.46)) list(0.2 0.2))
    hiRoute(f "SPI_NSS_BOTTOM_BRIDGE" "SPI_NSS" "BOTTOM" list(list(29.6 32.46) list(29.44 32.3) list(20.4 32.3) list(20.3 32.4)) list(0.2 0.2 0.2))
    hiRoute(f "SPI_NSS_WEST_TOP" "SPI_NSS" "TOP" list(list(20.3 32.4) list(16.54 36.16) list(7.0 36.16)) list(0.2 0.2))
    hiVia(f "SPI_RETURN_SCK_E" "GND" list(30.9 29.1) "L28_VIA030_C060")
    hiVia(f "SPI_RETURN_SCK_W" "GND" list(20.5 29.32) "L28_VIA030_C060")
    hiVia(f "SPI_RETURN_MOSI_E" "GND" list(32.8 25.3) "L28_VIA030_C060")
    hiVia(f "SPI_RETURN_MOSI_W" "GND" list(14.0 30.6) "L28_VIA030_C060")
    hiVia(f "SPI_RETURN_MISO_E" "GND" list(32.85 28.1) "L28_VIA030_C060")
    hiVia(f "SPI_RETURN_GUARD_E" "GND" list(27.1 31.55) "L28_VIA030_C060")
    hiVia(f "SPI_RETURN_GUARD_W" "GND" list(21.0 31.55) "L28_VIA030_C060")
    hiVia(f "SPI_RETURN_NSS_E" "GND" list(29.0 33.2) "L28_VIA030_C060")
    hiVia(f "SPI_RETURN_NSS_W" "GND" list(20.8 33.75) "L28_VIA030_C060")
    hiRoute(f "SPI_GUARD_CLOCK_MOSI" "GND" "BOTTOM" list(list(28.6 29.0) list(28.85 29.25) list(22.8 29.25)) list(0.6 0.6))
    hiRoute(f "SPI_GUARD_MISO_NSS" "GND" "BOTTOM" list(list(29.9 31.55) list(21.0 31.55)) list(0.6))
    hiHSEIsolationChallengeGraph("D:/001DIY/005lib/01AIEDA/learning/examples/lessonHI_38_50_20261021/logs/SPI_external_2L_b012" list(45.45 28.85) "BOTTOM" list(list(42.2 39.8) list(44.2 39.8) list(47.8 33.5)))
    t)
   progn(
    axlDBControl('drcEnable t)
    fprintf(f "HI_UNWIND_DRC_RESTORED=%L\n" axlDBControl('drcEnable))))
  unless(axlDBControl('drcEnable) error("Final DRC must be enabled\n"))
  hiFinalize(f "D:/001DIY/005lib/01AIEDA/learning/examples/lessonHI_38_50_20261021/logs/SPI_external_2L_b012" "D:/001DIY/005lib/01AIEDA/learning/examples/lessonHI_38_50_20261021/native/HI_2L_SPI_external_2L_b012.brd" "D:/001DIY/005lib/01AIEDA/learning/examples/lessonHI_38_50_20261021/library" list(list("R21.2" "J6.2" t) list("R22.2" "J6.3" t) list("R24.2" "J6.4" t) list("R23.2" "J6.5" t) list("SPI_RETURN_SCK_E" "U1.23" t) list("SPI_RETURN_SCK_W" "U1.23" t) list("SPI_RETURN_MOSI_E" "U1.23" t) list("SPI_RETURN_MOSI_W" "U1.23" t) list("SPI_RETURN_MISO_E" "U1.23" t) list("SPI_RETURN_GUARD_E" "U1.23" t) list("SPI_RETURN_GUARD_W" "U1.23" t) list("SPI_RETURN_NSS_E" "U1.23" t) list("SPI_RETURN_NSS_W" "U1.23" t) list("SPI_GUARD_CLOCK_MOSI" "U1.23" t) list("SPI_GUARD_MISO_NSS" "U1.23" t) list("C9.1" "SPI_PREFILTER_ROW_SHIFT" t)))
  t))
