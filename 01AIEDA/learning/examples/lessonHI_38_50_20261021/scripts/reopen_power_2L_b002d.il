procedure(hiReadbackProofs()
 let((f)
  f=outfile("D:/001DIY/005lib/01AIEDA/learning/examples/lessonHI_38_50_20261021/logs/reopen_power_2L_b002d/hi_reopen_endpoint_proofs.txt")
  hiRegistry=nil
  hiNodeDefinitions=list(list("IN_J1_F1" "VIN_RAW" "TOP" list(6.0 14.27) "point") list("IN_F1_D1" "VIN_FUSED" "TOP" list(10.8764 13.0) "point") list("IN_D1_C2" "VIN_PROT" "TOP" list(16.95 13.0) "point") list("IN_D1_C1" "VIN_PROT" "TOP" list(16.95 13.0) "point") list("IN_C1_GND" "GND" "TOP" list(12.45 18.3) "point") list("OUT_L1_C5" "V5" "TOP" list(17.98 24.0) "point") list("OUT_C5_C6" "V5" "TOP" list(14.4 23.1) "point") list("OUT_C5_C6_GND" "GND" "TOP" list(14.4 26.148) "point") list("OUT_GND_B" "GND" "TOP" list(13.0 26.148) "point") list("V5_LDO_MAIN" "V5" "TOP" list(14.4 23.1) "point") list("V5_C8_U3IN" "V5" "TOP" list(24.2 31.0) "point") list("V5_U3_EN" "V5" "TOP" list(25.7 29.95) "point") list("LDO_OUT_C9" "V3V3" "TOP" list(28.3 29.95) "point") list("LDO_C8_GND" "GND" "TOP" list(25.7 29.0) "point") list("LDO_C9_GND" "GND" "TOP" list(29.8 28.918) "point") list("V5_R1_C7" "V5" "TOP" list(30.8984 19.1) "point") list("FB_C7_R1" "BUCK_FB" "TOP" list(29.3236 17.3) "point") list("FB_U2_R2" "BUCK_FB" "TOP" list(26.8 20.05) "point") list("FB_R1_JOIN" "BUCK_FB" "TOP" list(29.3236 19.1) "point") list("FB_GND_QUIET" "GND" "TOP" list(28.2236 21.3) "point") list("V_HI_C1" "GND" "TOP" list(13.8 18.3) "via") list("V_HI_OUT_A" "GND" "TOP" list(13.0 26.148) "via") list("V_HI_OUT_B" "GND" "TOP" list(13.0 27.0) "via") list("V_HI_LDO_IN_A" "GND" "TOP" list(24.2 27.8) "via") list("V_HI_LDO_IN_B" "GND" "TOP" list(24.2 27.0) "via") list("V_HI_LDO_OUT_A" "GND" "TOP" list(28.6 29.0) "via") list("V_HI_LDO_OUT_B" "GND" "TOP" list(27.9 29.0) "via") list("V_HI_FB_GND" "GND" "TOP" list(28.2236 22.4) "via") list("V5_SENSE_TOP_SOURCE" "V5" "TOP" list(14.4 23.1) "point") list("V_HI_V5_SENSE_SOURCE" "V5" "TOP" list(15.5 22.0) "via") list("V5_SENSE_BOTTOM" "V5" "BOTTOM" list(15.5 22.0) "point") list("V_HI_V5_SENSE_END" "V5" "TOP" list(31.8 19.1) "via") list("V5_SENSE_TOP_END" "V5" "TOP" list(31.8 19.1) "point") list("V5_SENSE_2L_GND_BRIDGE" "GND" "TOP" list(13.8 18.3) "point") list("V_HI_INPUT_RETURN_BRIDGE" "GND" "TOP" list(16.5 15.5) "via"))
  hiBindExistingVia(f "V_HI_C1" "GND" list(13.8 18.3) "L28_VIA030_C060")
  hiBindExistingVia(f "V_HI_OUT_A" "GND" list(13.0 26.148) "L28_VIA030_C060")
  hiBindExistingVia(f "V_HI_OUT_B" "GND" list(13.0 27.0) "L28_VIA030_C060")
  hiBindExistingVia(f "V_HI_LDO_IN_A" "GND" list(24.2 27.8) "L28_VIA030_C060")
  hiBindExistingVia(f "V_HI_LDO_IN_B" "GND" list(24.2 27.0) "L28_VIA030_C060")
  hiBindExistingVia(f "V_HI_LDO_OUT_A" "GND" list(28.6 29.0) "L28_VIA030_C060")
  hiBindExistingVia(f "V_HI_LDO_OUT_B" "GND" list(27.9 29.0) "L28_VIA030_C060")
  hiBindExistingVia(f "V_HI_FB_GND" "GND" list(28.2236 22.4) "L28_VIA030_C060")
  hiBindExistingVia(f "V_HI_V5_SENSE_SOURCE" "V5" list(15.5 22.0) "L28_VIA030_C060")
  hiBindExistingVia(f "V_HI_V5_SENSE_END" "V5" list(31.8 19.1) "L28_VIA030_C060")
  hiBindExistingVia(f "V_HI_INPUT_RETURN_BRIDGE" "GND" list(16.5 15.5) "L28_VIA030_C060")
  hiProof(f "J1.1" "F1.1" t)
  hiProof(f "F1.2" "D1.2" t)
  hiProof(f "D1.1" "C2.1" t)
  hiProof(f "D1.1" "C1.1" t)
  hiProof(f "C1.2" "V_HI_C1" t)
  hiProof(f "L1.2" "C5.1" t)
  hiProof(f "C5.1" "C6.1" t)
  hiProof(f "C5.2" "C6.2" t)
  hiProof(f "V_HI_OUT_A" "V_HI_OUT_B" t)
  hiProof(f "C5.1" "C8.1" t)
  hiProof(f "C8.1" "U3.1" t)
  hiProof(f "U3.1" "U3.3" t)
  hiProof(f "U3.5" "C9.1" t)
  hiProof(f "U3.2" "V_HI_LDO_IN_B" t)
  hiProof(f "C9.2" "V_HI_LDO_OUT_B" t)
  hiProof(f "R1.1" "C7.1" t)
  hiProof(f "C7.2" "R1.2" t)
  hiProof(f "U2.4" "R2.1" t)
  hiProof(f "R1.2" "FB_U2_R2" t)
  hiProof(f "R2.2" "V_HI_FB_GND" t)
  hiProof(f "C5.1" "V_HI_V5_SENSE_SOURCE" t)
  hiProof(f "V_HI_V5_SENSE_SOURCE" "V_HI_V5_SENSE_END" t)
  hiProof(f "V_HI_V5_SENSE_END" "R1.1" t)
  hiProof(f "V_HI_C1" "V_HI_INPUT_RETURN_BRIDGE" t)
  fprintf(f "HI_REOPEN_ALL_ENDPOINTS_COMPLETE\n") close(f) t))
