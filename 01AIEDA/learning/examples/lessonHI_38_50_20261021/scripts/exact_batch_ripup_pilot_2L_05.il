procedure(hiExactPilot() let((f mark) f=outfile("D:/001DIY/005lib/01AIEDA/learning/examples/lessonHI_38_50_20261021/logs/exact_batch_ripup_pilot_2L_05/pilot.txt") mark=axlDBTransactionStart() unwindProtect(progn(axlDBControl('drcEnable nil) hiDeleteExactBatch(f list(list("deleteVia" "NSS01_DEL_VIA_[39, 26.2]" "PA4_SPI_NSS" "" list(39 26.2) "L28_VIA030_C060") list("deleteVia" "NSS01_DEL_VIA_[32.2, 22]" "PA4_SPI_NSS" "" list(32.2 22) "L28_VIA030_C060") list("deleteVia" "OLD_PC14" "GPIO_PC14" "" list(45.6 25.2) "L28_VIA030_C060") list("deleteVia" "OLD_PC14_GND" "GND" "" list(46.95 24.9) "L28_VIA030_C060") list("deleteVia" "OLD_HSE_ANCHOR" "GND" "" list(45.45 28.85) "L28_VIA030_C060") list("deleteVia" "OLD_C15_COMMON_GND" "GND" "" list(47.45 28.7252) "L28_VIA030_C060") list("deleteSegment" "GPIO_NORTH_RIP_PC15_VERTICAL" "GPIO_PC15" "BOTTOM" list(list(40.3 28.9) list(40.3 30.3)) 0.2) list("deleteSegment" "GPIO_NORTH_RIP_PC15_WEST" "GPIO_PC15" "BOTTOM" list(list(40.3 30.3) list(35.4 30.3)) 0.2) list("deleteSegment" "SOUTH_RIP_C14_GND_0" "GND" "TOP" list(list(42.25 22.75) list(42.25 21.95)) 0.25) list("deleteSegment" "SOUTH_RIP_C14_GND_1" "GND" "TOP" list(list(42.25 21.95) list(41.85 21.55)) 0.25) list("deleteSegment" "SOUTH_RIP_C14_GND_2" "GND" "TOP" list(list(41.85 21.55) list(42.3252 21.0748)) 0.6) list("deleteSegment" "SOUTH_RIP_C14_GND_3" "GND" "TOP" list(list(42.3252 21.0748) list(42.3252 20.3)) 0.6) list("deleteSegment" "LEFT_RIP_0" "GND" "TOP" list(list(35.75 24.75) list(34.95 24.75)) 0.25) list("deleteSegment" "LEFT_RIP_1" "GND" "TOP" list(list(34.95 24.75) list(34.55 25.15)) 0.25) list("deleteSegment" "LEFT_RIP_2" "GND" "TOP" list(list(34.55 25.15) list(33.4 25.2748)) 0.6) list("deleteSegment" "LEFT_RIP_3" "GND" "TOP" list(list(33.4 25.2748) list(32.45 25.2748)) 0.6) list("deleteSegment" "LEFT_RIP_4" "V3V3" "TOP" list(list(35.75 24.25) list(34.95 24.25)) 0.25) list("deleteSegment" "LEFT_RIP_5" "V3V3" "TOP" list(list(34.95 24.25) list(34.55 23.85)) 0.25) list("deleteSegment" "LEFT_RIP_6" "V3V3" "TOP" list(list(34.55 23.85) list(33.4 23.7)) 0.6) list("deleteSegment" "LEFT_RIP_7" "V3V3" "TOP" list(list(33.3 22.5) list(33.3 24)) 0.6) list("deleteSegment" "LEFT_RIP_8" "V3V3" "TOP" list(list(33.3 24) list(37 24)) 0.6) list("deleteSegment" "NSS01_DEL_0" "PA4_SPI_NSS" "TOP" list(list(35.75 29.25) list(36.8 29.25)) 0.2) list("deleteSegment" "NSS01_DEL_1" "PA4_SPI_NSS" "TOP" list(list(36.8 29.25) list(39 27.05)) 0.2) list("deleteSegment" "NSS01_DEL_2" "PA4_SPI_NSS" "TOP" list(list(39 27.05) list(39 26.2)) 0.2) list("deleteSegment" "NSS01_DEL_3" "PA4_SPI_NSS" "BOTTOM" list(list(39 26.2) list(39 21.3)) 0.2) list("deleteSegment" "NSS01_DEL_4" "PA4_SPI_NSS" "BOTTOM" list(list(39 21.3) list(32.2 21.3)) 0.2) list("deleteSegment" "NSS01_DEL_5" "PA4_SPI_NSS" "BOTTOM" list(list(32.2 21.3) list(32.2 22)) 0.2) list("deleteSegment" "NSS01_DEL_6" "PA4_SPI_NSS" "TOP" list(list(32.2 22) list(32 21)) 0.2) list("deleteSegment" "NSS01_DEL_9" "PA4_SPI_NSS" "TOP" list(list(32.93 33.02) list(32.7984 33.02)) 0.2) list("deleteSegment" "NSS01_DEL_10" "PA4_SPI_NSS" "TOP" list(list(34.8 31.15) list(32.93 33.02)) 0.2) list("deleteSegment" "NSS01_DEL_13" "PA5_SPI_SCK" "TOP" list(list(34.385 30.215) list(33.6 31)) 0.2) list("deleteSegment" "NSS01_DEL_15" "ADC0" "TOP" list(list(32.8 35) list(32.6764 35)) 0.2) list("deleteSegment" "NSS01_DEL_16" "ADC0" "TOP" list(list(34.8 33) list(32.8 35)) 0.2) list("deleteSegment" "NSS01_DEL_17" "ADC_IN" "TOP" list(list(29.8 34) list(26.27 34)) 0.2) list("deleteSegment" "NSS01_DEL_18" "ADC_IN" "TOP" list(list(30.8 35) list(29.8 34)) 0.2) list("deleteSegment" "NSS01_DEL_19" "ADC_IN" "TOP" list(list(31.1016 35) list(30.8 35)) 0.2) list("deleteSegment" "NSS01_2L_DEL_0" "SPI_SCK" "TOP" list(list(31.85 31) list(30.8 29.95)) 0.2) list("deleteSegment" "NSS01_2L_DEL_1" "SPI_SCK" "TOP" list(list(32.0252 31) list(31.85 31)) 0.2) list("deleteSegment" "NSS01_2L_DEL_3" "SPI_NSS" "TOP" list(list(30.16 33.02) list(29.6 32.46)) 0.2) list("deleteSegment" "NSS01_2L_DEL_4" "SPI_NSS" "TOP" list(list(31.2236 33.02) list(30.16 33.02)) 0.2) list("deleteSegment" "RIGHT_RIP_0" "GND" "TOP" list(list(45.05 29.25) list(45.45 28.85)) 0.25) list("deleteSegment" "RIGHT_RIP_1" "GND" "TOP" list(list(44.25 29.25) list(45.05 29.25)) 0.25) list("deleteSegment" "RIGHT_RIP_2" "GND" "TOP" list(list(45.45 28.85) list(46.5 28.7252)) 0.6) list("deleteSegment" "RIGHT_RIP_3" "GND" "TOP" list(list(46.5 28.7252) list(47.45 28.7252)) 0.6) list("deleteSegment" "RIGHT_RIP_4" "GND" "TOP" list(list(47.9428 28.7252) list(47.45 28.7252)) 0.6) list("deleteSegment" "RIGHT_RIP_5" "GND" "TOP" list(list(48.4 28.268) list(47.9428 28.7252)) 0.6) list("deleteSegment" "RIGHT_RIP_6" "GND" "TOP" list(list(49.5 28.268) list(48.4 28.268)) 0.6) list("deleteSegment" "RIGHT_RIP_7" "V3V3" "TOP" list(list(45.45 30.15) list(46.5 30.3)) 0.6) list("deleteSegment" "RIGHT_RIP_8" "V3V3" "TOP" list(list(45.05 29.75) list(45.45 30.15)) 0.25) list("deleteSegment" "RIGHT_RIP_9" "V3V3" "TOP" list(list(44.25 29.75) list(45.05 29.75)) 0.25) list("deleteSegment" "RIGHT_RIP_10" "V3V3" "TOP" list(list(49.5 30.3) list(46.5 30.3)) 0.6) list("deleteSegment" "RIGHT_RIP_11" "GPIO_PC14" "BOTTOM" list(list(43.6 25.2) list(45.6 25.2)) 0.2))) t) progn(axlDBTransactionRollback(mark) axlDBRefreshId(nil) axlDBControl('drcEnable t))) fprintf(f "EXACT_BATCH_PILOT_ROLLBACK_COMPLETE_NO_SAVE\n") close(f) t))
