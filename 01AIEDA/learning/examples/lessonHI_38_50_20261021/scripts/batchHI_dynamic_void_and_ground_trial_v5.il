procedure(hiXYClose(a b) abs(car(a)-car(b))<0.00011 && abs(cadr(a)-cadr(b))<0.00011)
hiGroundTrialHealthCount=0
procedure(hiShape(f id net layer points dynamic voids)
 let((shape ret geometry)
  geometry=if(equal(points "ROUTE_KEEPIN") then car(axlPolyFromDB(axlDBGetDesign()->keepinRoute)) else hiClosedPath(points))
  shape=axlDBCreateOpenShape(geometry t strcat("ETCH/" layer) net)
  unless(shape error("Cannot create actualshapeoutline\n"))
  unless(dynamic foreach(v voids unless(axlDBCreateVoid(shape hiClosedPath(v)) error("Cannot create staticvoid\n"))))
  ret=axlDBCreateCloseShape(shape t) unless(ret error("Cannot close actualshapeoutline\n")) shape=car(ret)
  when(dynamic shape=axlShapeChangeDynamicType(shape t t) unless(shape error("Cannot convert outline todynamicBOUNDARY\n")))
  hiReg(id "shape" shape)
  when(dynamic
   foreach(v voids hiVoid(f id v))
   shape=caddr(assoc(id hiRegistry))
   unless(equal(axlShapeDynamicUpdate(shape t) 0) error("Dynamicpermanentvoid shapeupdate failed\n")))
  fprintf(f "HI_SHAPE_SUPPORTED_DYNAMIC_VOID_ORDER id=%L dynamic=%L requestedVoidCount=%d actual=%L\n" id dynamic length(voids) shape->??)
  unless(length(shape->voids)==length(voids) error("New globalpermanentvoid count differs\n"))
  foreach(h shape->voids fprintf(f "HI_NEW_GLOBAL_VOID_ACTUAL_POLY=%L\n" car(axlPolyFromDB(h))->vertices))
  foreach(v voids unless(length(setof(h shape->voids hiPolygonMatches(h v)))==1 error("Newglobalpermanentvoid polygon differs\n")))
  when(equal(id "B018_APP_TOP_TRIAL") hiRemoveActualUnconnectedTopFragments(f shape)) shape))
procedure(hiRetireReplacedTopReferences(f)
 let((kept)
  kept=nil
  foreach(r hiDeferredReferences
   if(equal(cadr(r) "TOP") then
    fprintf(f "HI_TOP_OLD_MOTHER_INTENTIONALLY_REPLACED_BY_SINGLE_GLOBAL definition=%L\n" r)
   else kept=append(kept list(r))))
  hiDeferredReferences=kept t))
procedure(hiGroundTrialHealth(out expectedPins expectedVias)
 let((f graph pins vias missing shapes orphan ood orphanBranches allpins bg terminals)
  when(expectedVias==84 && hiGroundTrialHealthCount==0 hiRemoveExplicitNorthBottomFragment(out))
  hiGroundTrialHealthCount=hiGroundTrialHealthCount+1
  f=outfile(sprintf(nil "%s/hi_all_ground_common_trial_%d.txt" out hiGroundTrialHealthCount))
  unless(equal(axlShapeDynamicUpdate(nil t) 0) error("Groundtrialforcefill failed\n")) axlDBRefreshId(nil)
  graph=gConnectedObjects(gPin("C1" "2")) pins=0 vias=0 missing=0 shapes=0 orphan=0 ood=0 orphanBranches=0 allpins=nil
  foreach(c axlDBGetDesign()->components
   foreach(p c->symbol->pins
    when(p->net && member(p->net axlDBGetDesign()->nets) allpins=cons(p allpins))
    when(p->net && equal(p->net->name "GND")
     pins=pins+1
     fprintf(f "ALL_GND_PHYSICAL_PIN ref=%L number=%L xy=%L globalC1_2Reached=%L\n" c->name p->number p->xy if(member(p graph) then t else nil))
     unless(member(p graph) missing=missing+1))))
  foreach(v hiAllVias()
   when(v->net && equal(v->net->name "GND")
    vias=vias+1 fprintf(f "ALL_GND_ACTUAL_VIA xy=%L padstack=%L commonC1_2=%L\n" v->xy v->name if(member(v graph) then t else nil))
    unless(member(v graph) missing=missing+1)))
  foreach(s axlDBGetShapes("ETCH")
   when(s->net && equal(s->net->name "GND") && s->fill && !s->shapeIsBoundary
    shapes=shapes+1
    unless(member(s graph) orphan=orphan+1 fprintf(f "ACTUAL_GND_SHAPE_WITHOUT_COMMON=%L polygon=%L\n" s->?? car(axlPolyFromDB(s))->vertices))))
  foreach(b axlDBGetShapes("BOUNDARY")
   when(b->fillOOD ood=ood+1 fprintf(f "OUT_OF_DATE_DYNAMIC_BOUNDARY=%L\n" b->??)))
  foreach(net axlDBGetDesign()->nets
   foreach(branch net->branches
    bg=nil
    foreach(child branch->children foreach(obj gConnectedObjects(child) unless(member(obj bg) bg=cons(obj bg))))
    terminals=setof(p allpins member(p bg))
    unless(terminals orphanBranches=orphanBranches+1 fprintf(f "NO_TERMINAL_BRANCH_TRIAL net=%L branch=%L graph=%L\n" net->name branch->?? bg))))
  fprintf(f "GROUND_TRIAL_SUMMARY pins=%d expectedPins=%d vias=%d expectedVias=%d missing=%d actualGroundShapes=%d shapesWithoutCommon=%d outOfDate=%d allNetTerminalFreeBranches=%d drcEnable=%L designModes=%L\n" pins expectedPins vias expectedVias missing shapes orphan ood orphanBranches axlDBControl('drcEnable) axlCNSDesignModeGet('all)) drain(f)
  unless(pins==expectedPins && vias==expectedVias && missing==0 && orphan==0 && ood==0 && orphanBranches==0 progn(gSnapshot(out hiDiagnosticLibrary) hiNetworkInventory(out) hiExtraRead(out) hiShapeBoundaryRead(out) hiRouteRoles(out) hiBranchAudit(out) error("Groundtrial actualcommon/fill/orphan health failed; preserveactualdiagnostics, noSave\n")))
  fprintf(f "GROUND_TRIAL_ALL_POSITIVE_COMMON_HEALTH_COMPLETE_NOT_FINAL_REFERENCE_CERTIFICATION\n") close(f) t))

procedure(hiRemoveActualUnconnectedTopFragments(f mother)
 let((common candidates allterm graph poly ret)
  axlDBRefreshId(nil) common=gConnectedObjects(gPin("C1" "2")) candidates=nil allterm=hiAllVias()
  foreach(c axlDBGetDesign()->components foreach(p c->symbol->pins allterm=cons(p allterm)))
  foreach(s axlDBGetShapes("ETCH/TOP")
   when(s->shapeBoundary && equal(s->shapeBoundary mother) && !member(s common)
    graph=gConnectedObjects(s)
    when(exists(p allterm member(p graph)) error("Refuse to delete isolated copper with any real pin or via\n"))
    poly=car(axlPolyFromDB(s)) unless(poly error("Cannot read actual generated island polygon\n"))
    fprintf(f "HI_TOP_GENERATED_NO_TERMINAL_FRAGMENT_PRE_VOID attributes=%L polyArea=%L realArcPolygon=%L\n" s->?? poly->area poly->vertices)
    candidates=append(candidates list(poly))))
  foreach(poly candidates
   ret=axlDBCreateVoid(mother poly)
   unless(ret error("Cannot create permanent void from actual no-terminal fragment\n"))
   fprintf(f "HI_TOP_ISLAND_REMOVAL_PERMANENT_VOID actual=%L originalArea=%L\n" ret->?? poly->area))
  unless(equal(axlShapeDynamicUpdate(mother t) 0) error("Cannot refill after controlled real island removal\n"))
  fprintf(f "HI_TOP_FRAGMENT_CLEANUP_COUNT=%d PRESERVED_ORIGINAL_QUIET_VOID=t GLOBAL_PARAMETERS_UNCHANGED=t\n" length(candidates)) t))

procedure(hiRemoveExplicitNorthBottomFragment(out)
 let((f matches s mother poly graph allterm ret expected actual ok)
  f=outfile(strcat(out "/hi_explicit_bottom_trial_fragment.txt"))
  expected='(((18.7577 54.2236) 0.9302016) ((18.7018 54.2403) -0.1016011) ((18.6002 54.1388) 0.1016011) ((18.6002 49.3658) 0.0) ((18.6764 49.2896) 0.0) ((18.7482 49.2598) 0.1015894) ((18.8498 49.3614) -0.1015894) ((18.8498 54.1701) 0.0))
  axlDBRefreshId(nil)
  matches=setof(x axlDBGetShapes("ETCH/BOTTOM") x->net && equal(x->net->name "GND") && x->shapeBoundary && hiXYClose(car(x->bBox) list(18.6002 49.2599)) && hiXYClose(cadr(x->bBox) list(18.8498 54.2404)))
  unless(length(matches)==1 error("Explicit authorized BOTTOM island not unique\n")) s=car(matches) mother=s->shapeBoundary
  unless(equal(mother->layer "BOUNDARY/BOTTOM") && mother->shapeIsBoundary error("Explicit orphan is not application BOTTOM dynamicgenerated\n"))
  graph=gConnectedObjects(s) allterm=hiAllVias()
  foreach(c axlDBGetDesign()->components foreach(p c->symbol->pins allterm=cons(p allterm)))
  when(exists(p allterm member(p graph)) error("Refuse BOTTOM island removal with real pin/via\n"))
  poly=car(axlPolyFromDB(s)) actual=poly->vertices ok=length(actual)==length(expected)
  when(ok for(k 0 length(expected)-1 unless(hiXYClose(car(nth(k actual)) car(nth(k expected))) && abs(cadr(nth(k actual))-cadr(nth(k expected)))<0.00001 ok=nil)))
  unless(ok && abs(poly->area-1.228451)<0.00001 error("Explicit authorized BOTTOM island real arc polygon differs\n"))
  fprintf(f "EXPLICIT_STAGE_BOTTOM_ISLAND_ID=B018_BOTTOM_NORTH_FRAGMENT_01\nPRE_ACTUAL=%L\nMOTHER_BEFORE=%L\nAREA=%L\nREAL_ARC_POLYGON=%L\n" s->?? mother->?? poly->area actual)
  ret=axlDBCreateVoid(mother poly) unless(ret error("Cannot create authorized BOTTOM fragment permanentvoid\n"))
  fprintf(f "NEW_STAGE_VOID=%L\nORIGINAL_APPLICATION_BOUNDARY_AND_EXISTING_VOIDS_RETAINED=t\n" ret->??)
  unless(equal(axlShapeDynamicUpdate(mother t) 0) error("Cannot forcefill BOTTOM after stage void\n")) close(f) t))
