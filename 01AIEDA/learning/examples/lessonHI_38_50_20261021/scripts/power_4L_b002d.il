procedure(hiBatchProgram()
 let((f)
  f=outfile("D:/001DIY/005lib/01AIEDA/learning/examples/lessonHI_38_50_20261021/logs/power_4L_b002d/hi_batch_execution.txt")
  hiRegistry=nil
  hiNodeDefinitions=list(list("IN_J1_F1" "VIN_RAW" "TOP" list(6.0 14.27) "point") list("IN_F1_D1" "VIN_FUSED" "TOP" list(10.8764 13.0) "point") list("IN_D1_C2" "VIN_PROT" "TOP" list(16.95 13.0) "point") list("IN_D1_C1" "VIN_PROT" "TOP" list(16.95 13.0) "point") list("IN_C1_GND" "GND" "TOP" list(12.45 18.3) "point") list("OUT_L1_C5" "V5" "TOP" list(17.98 24.0) "point") list("OUT_C5_C6" "V5" "TOP" list(14.4 23.1) "point") list("OUT_C5_C6_GND" "GND" "TOP" list(14.4 26.148) "point") list("OUT_GND_B" "GND" "TOP" list(13.0 26.148) "point") list("V5_LDO_MAIN" "V5" "TOP" list(14.4 23.1) "point") list("V5_C8_U3IN" "V5" "TOP" list(24.2 31.0) "point") list("V5_U3_EN" "V5" "TOP" list(25.7 29.95) "point") list("LDO_OUT_C9" "V3V3" "TOP" list(28.3 29.95) "point") list("LDO_C8_GND" "GND" "TOP" list(25.7 29.0) "point") list("LDO_C9_GND" "GND" "TOP" list(29.8 28.918) "point") list("V5_R1_C7" "V5" "TOP" list(30.8984 19.1) "point") list("FB_C7_R1" "BUCK_FB" "TOP" list(29.3236 17.3) "point") list("FB_U2_R2" "BUCK_FB" "TOP" list(26.8 20.05) "point") list("FB_R1_JOIN" "BUCK_FB" "TOP" list(29.3236 19.1) "point") list("FB_GND_QUIET" "GND" "TOP" list(28.2236 21.3) "point") list("V_HI_C1" "GND" "TOP" list(13.8 18.3) "via") list("V_HI_OUT_A" "GND" "TOP" list(13.0 26.148) "via") list("V_HI_OUT_B" "GND" "TOP" list(13.0 27.0) "via") list("V_HI_LDO_IN_A" "GND" "TOP" list(24.2 27.8) "via") list("V_HI_LDO_IN_B" "GND" "TOP" list(24.2 27.0) "via") list("V_HI_LDO_OUT_A" "GND" "TOP" list(28.6 29.0) "via") list("V_HI_LDO_OUT_B" "GND" "TOP" list(27.9 29.0) "via") list("V_HI_FB_GND" "GND" "TOP" list(28.2236 22.4) "via") list("V5_SENSE_TOP_SOURCE" "V5" "TOP" list(14.4 23.1) "point") list("V_HI_V5_SENSE_SOURCE" "V5" "TOP" list(15.5 22.0) "via") list("V5_SENSE_BOTTOM" "V5" "BOTTOM" list(15.5 22.0) "point") list("V_HI_V5_SENSE_END" "V5" "TOP" list(31.8 19.1) "via") list("V5_SENSE_TOP_END" "V5" "TOP" list(31.8 19.1) "point") list("V5_SENSE_2L_GND_BRIDGE" "GND" "TOP" list(13.8 18.3) "point") list("V_HI_INPUT_RETURN_BRIDGE" "GND" "TOP" list(16.5 15.5) "via"))
  hiShape(f "HI_GND_L3" "GND" "L3" "ROUTE_KEEPIN" t list())
  hiRoute(f "IN_J1_F1" "VIN_RAW" "TOP" list(list(6.0 14.27) list(7.9 14.27) list(9.3016 13.0)) list(0.6 0.6))
  hiRoute(f "IN_F1_D1" "VIN_FUSED" "TOP" list(list(10.8764 13.0) list(13.1 13.0)) list(0.6))
  hiRoute(f "IN_D1_C2" "VIN_PROT" "TOP" list(list(16.95 13.0) list(16.95 10.6) list(25.2 10.6) list(25.2 15.4)) list(0.6 0.6 0.6))
  hiRoute(f "IN_D1_C1" "VIN_PROT" "TOP" list(list(16.95 13.0) list(17.5 13.55) list(17.5 16.2) list(14.0 19.7) list(9.95 19.7) list(9.95 18.3)) list(0.6 0.6 0.6 0.6 0.6))
  hiRoute(f "IN_C1_GND" "GND" "TOP" list(list(12.45 18.3) list(13.8 18.3)) list(0.6))
  hiRoute(f "OUT_L1_C5" "V5" "TOP" list(list(17.98 24.0) list(16.8 24.0) list(15.9 23.1) list(14.4 23.1)) list(0.8 0.8 0.8))
  hiRoute(f "OUT_C5_C6" "V5" "TOP" list(list(14.4 23.1) list(11.7 23.1)) list(0.8))
  hiRoute(f "OUT_C5_C6_GND" "GND" "TOP" list(list(14.4 26.148) list(13.0 26.148) list(11.7 26.148)) list(0.8 0.8))
  hiRoute(f "OUT_GND_B" "GND" "TOP" list(list(13.0 26.148) list(13.0 27.0)) list(0.8))
  hiRoute(f "V5_LDO_MAIN" "V5" "TOP" list(list(14.4 23.1) list(16.0 24.7) list(16.0 28.4) list(22.8 28.4) list(22.8 31.0) list(24.2 31.0)) list(0.6 0.6 0.6 0.6 0.6))
  hiRoute(f "V5_C8_U3IN" "V5" "TOP" list(list(24.2 31.0) list(25.0 31.0) list(25.7 30.3) list(25.7 29.95)) list(0.6 0.6 0.6))
  hiRoute(f "V5_U3_EN" "V5" "TOP" list(list(25.7 29.95) list(26.95 29.95) list(26.95 28.05) list(25.7 28.05)) list(0.6 0.6 0.6))
  hiRoute(f "LDO_OUT_C9" "V3V3" "TOP" list(list(28.3 29.95) list(28.3 30.5) list(28.75 30.95) list(29.8 30.95)) list(0.6 0.6 0.6))
  hiRoute(f "LDO_C8_GND" "GND" "TOP" list(list(25.7 29.0) list(24.2 28.968) list(24.2 27.8) list(24.2 27.0)) list(0.6 0.6 0.6))
  hiRoute(f "LDO_C9_GND" "GND" "TOP" list(list(29.8 28.918) list(29.8 29.0) list(28.6 29.0) list(27.9 29.0)) list(0.6 0.6 0.6))
  hiRoute(f "V5_R1_C7" "V5" "TOP" list(list(30.8984 19.1) list(30.8984 17.3)) list(0.6))
  hiRoute(f "FB_C7_R1" "BUCK_FB" "TOP" list(list(29.3236 17.3) list(29.3236 19.1)) list(0.2))
  hiRoute(f "FB_U2_R2" "BUCK_FB" "TOP" list(list(26.8 20.05) list(29.3236 20.05) list(29.7984 20.5248) list(29.7984 21.3)) list(0.2 0.2 0.2))
  hiRoute(f "FB_R1_JOIN" "BUCK_FB" "TOP" list(list(29.3236 19.1) list(29.3236 20.05)) list(0.2))
  hiRoute(f "FB_GND_QUIET" "GND" "TOP" list(list(28.2236 21.3) list(28.2236 22.4)) list(0.6))
  hiVia(f "V_HI_C1" "GND" list(13.8 18.3) "L28_VIA030_C060")
  hiVia(f "V_HI_OUT_A" "GND" list(13.0 26.148) "L28_VIA030_C060")
  hiVia(f "V_HI_OUT_B" "GND" list(13.0 27.0) "L28_VIA030_C060")
  hiVia(f "V_HI_LDO_IN_A" "GND" list(24.2 27.8) "L28_VIA030_C060")
  hiVia(f "V_HI_LDO_IN_B" "GND" list(24.2 27.0) "L28_VIA030_C060")
  hiVia(f "V_HI_LDO_OUT_A" "GND" list(28.6 29.0) "L28_VIA030_C060")
  hiVia(f "V_HI_LDO_OUT_B" "GND" list(27.9 29.0) "L28_VIA030_C060")
  hiVia(f "V_HI_FB_GND" "GND" list(28.2236 22.4) "L28_VIA030_C060")
  hiRoute(f "V5_SENSE_TOP_SOURCE" "V5" "TOP" list(list(14.4 23.1) list(15.5 22.0)) list(0.6))
  hiVia(f "V_HI_V5_SENSE_SOURCE" "V5" list(15.5 22.0) "L28_VIA030_C060")
  hiRoute(f "V5_SENSE_BOTTOM" "V5" "BOTTOM" list(list(15.5 22.0) list(15.5 12.0) list(31.8 12.0) list(31.8 19.1)) list(0.6 0.6 0.6))
  hiVia(f "V_HI_V5_SENSE_END" "V5" list(31.8 19.1) "L28_VIA030_C060")
  hiRoute(f "V5_SENSE_TOP_END" "V5" "TOP" list(list(31.8 19.1) list(30.8984 19.1)) list(0.6))
  hiRoute(f "V5_SENSE_2L_GND_BRIDGE" "GND" "TOP" list(list(13.8 18.3) list(13.8 15.5) list(16.5 15.5)) list(0.6 0.6))
  hiVia(f "V_HI_INPUT_RETURN_BRIDGE" "GND" list(16.5 15.5) "L28_VIA030_C060")
  hiFinalize(f "D:/001DIY/005lib/01AIEDA/learning/examples/lessonHI_38_50_20261021/logs/power_4L_b002d" "D:/001DIY/005lib/01AIEDA/learning/examples/lessonHI_38_50_20261021/native/HI_4L_power_4L_b002d.brd" "D:/001DIY/005lib/01AIEDA/learning/examples/lessonHI_38_50_20261021/library" list(list("J1.1" "F1.1" t) list("F1.2" "D1.2" t) list("D1.1" "C2.1" t) list("D1.1" "C1.1" t) list("C1.2" "V_HI_C1" t) list("L1.2" "C5.1" t) list("C5.1" "C6.1" t) list("C5.2" "C6.2" t) list("V_HI_OUT_A" "V_HI_OUT_B" t) list("C5.1" "C8.1" t) list("C8.1" "U3.1" t) list("U3.1" "U3.3" t) list("U3.5" "C9.1" t) list("U3.2" "V_HI_LDO_IN_B" t) list("C9.2" "V_HI_LDO_OUT_B" t) list("R1.1" "C7.1" t) list("C7.2" "R1.2" t) list("U2.4" "R2.1" t) list("R1.2" "FB_U2_R2" t) list("R2.2" "V_HI_FB_GND" t) list("C5.1" "V_HI_V5_SENSE_SOURCE" t) list("V_HI_V5_SENSE_SOURCE" "V_HI_V5_SENSE_END" t) list("V_HI_V5_SENSE_END" "R1.1" t) list("V_HI_C1" "V_HI_INPUT_RETURN_BRIDGE" t)))
  t))
