procedure(hiReadbackProofs()
 let((f)
  f=outfile("D:/001DIY/005lib/01AIEDA/learning/examples/lessonHI_38_50_20261021/logs/reopen_mcu_2L_b006/hi_reopen_endpoint_proofs.txt")
  hiRegistry=nil
  hiNodeDefinitions=list(list("HSE_IN" "OSC_IN" "TOP" list(40.75 31.25) "point") list("HSE_IN_LOAD" "OSC_IN" "TOP" list(44.4 33.7) "point") list("HSE_OUT" "OSC_OUT" "TOP" list(40.25 31.25) "point") list("HSE_XTAL_OUT" "XTAL_OUT" "TOP" list(40.2 34.7748) "point") list("HSE_OUT_LOAD" "XTAL_OUT" "TOP" list(40.3 37.7) "point") list("HSE_LOCAL_C22" "GND" "TOP" list(47.1 35.5748) "via") list("HSE_LOCAL_C23" "GND" "TOP" list(37.7 37.7) "via") list("HSE_SINGLE_ANCHOR" "GND" "TOP" list(45.45 28.85) "via") list("HSE_C22_RETURN" "GND" "TOP" list(46.2 35.5748) "point") list("HSE_C23_RETURN" "GND" "TOP" list(38.2252 37.7) "point") list("HSE_GUARD_LEFT_NORTH" "GND" "TOP" list(37.7 37.7) "point") list("HSE_GUARD_RIGHT_NORTH" "GND" "TOP" list(47.1 35.5748) "point") list("HSE_GUARD_RIGHT_LOWER" "GND" "TOP" list(47.8 35.5748) "point") list("HSE_CASE_APP" "GND" "TOP" list(43.2 40.8) "via") list("HSE_CASE4_APP" "GND" "TOP" list(42.0 33.7) "point") list("HSE_CASE2_APP" "GND" "TOP" list(44.4 37.7) "point") list("VDDA_PIN_CAP" "VDDA" "TOP" list(38.75 31.25) "point") list("VDDA_CAP_BULK" "VDDA" "TOP" list(37.0 33.2) "point") list("VDDA_BULKS" "VDDA" "TOP" list(34.8 37.0) "point") list("VDDA_FILTER" "VDDA" "TOP" list(32.2 37.0) "point") list("VSSA8_APP" "GND" "TOP" list(38.7 29.5) "via") list("VSSA8_INWARD" "GND" "TOP" list(39.25 31.25) "point") list("C18_APP_GND" "GND" "TOP" list(37.9 34.7748) "via") list("C18_APP_GND_TRACE" "GND" "TOP" list(37.0 34.7748) "point") list("C19_APP_GND" "GND" "TOP" list(34.8 39.7) "via") list("C19_APP_GND_TRACE" "GND" "TOP" list(34.8 38.5748) "point") list("C20_APP_GND" "GND" "TOP" list(32.2 40.1) "via") list("C20_APP_GND_TRACE" "GND" "TOP" list(32.2 39.032) "point") list("C24_APP_GND" "GND" "TOP" list(34.4 35.7) "via") list("C24_APP_GND_TRACE" "GND" "TOP" list(34.8 34.5748) "point") list("C21_APP_GND" "GND" "TOP" list(36.95 36.25) "via") list("C21_APP_GND_TRACE" "GND" "TOP" list(37.8016 36.25) "point") list("ADC_PIN_CAP" "ADC0" "TOP" list(38.25 31.25) "point") list("ADC_CAP_SERIES" "ADC0" "TOP" list(34.8 33.0) "point") list("ADC_INPUT" "ADC_IN" "TOP" list(31.1016 35.0) "point") list("NRST_PIN_CAP" "NRST" "TOP" list(39.75 31.25) "point") list("NRST_SERVICE" "NRST" "TOP" list(38.7 35.3) "via") list("NRST_SERVICE_TAP" "NRST" "TOP" list(39.35 35.3) "point") list("VBAT_PIN_CAP" "V3V3" "TOP" list(42.75 31.25) "point") list("VBAT_C17_APP" "GND" "TOP" list(48.9 32.4) "via") list("VBAT_C17_RETURN" "GND" "TOP" list(47.7764 32.4) "point") list("HI_GUARD_LEFT_END" "GND" "TOP" list(42.2 39.8) "point") list("HI_GUARD_RIGHT_END" "GND" "TOP" list(44.2 39.8) "point") list("HI_GUARD_RIGHT_LOWER_END" "GND" "TOP" list(47.8 33.5) "point"))
  hiBindExistingStaticShape(f "HI_HSE_QUIET" "GND" "BOTTOM")
  hiBindExistingVia(f "HSE_LOCAL_C22" "GND" list(47.1 35.5748) "L28_VIA030_C060")
  hiBindExistingVia(f "HSE_LOCAL_C23" "GND" list(37.7 37.7) "L28_VIA030_C060")
  hiBindExistingVia(f "HSE_SINGLE_ANCHOR" "GND" list(45.45 28.85) "L28_VIA030_C060")
  hiBindExistingVia(f "HSE_CASE_APP" "GND" list(43.2 40.8) "L28_VIA030_C060")
  hiBindExistingVia(f "VSSA8_APP" "GND" list(38.7 29.5) "L28_VIA030_C060")
  hiBindExistingVia(f "C18_APP_GND" "GND" list(37.9 34.7748) "L28_VIA030_C060")
  hiBindExistingVia(f "C19_APP_GND" "GND" list(34.8 39.7) "L28_VIA030_C060")
  hiBindExistingVia(f "C20_APP_GND" "GND" list(32.2 40.1) "L28_VIA030_C060")
  hiBindExistingVia(f "C24_APP_GND" "GND" list(34.4 35.7) "L28_VIA030_C060")
  hiBindExistingVia(f "C21_APP_GND" "GND" list(36.95 36.25) "L28_VIA030_C060")
  hiBindExistingVia(f "NRST_SERVICE" "NRST" list(38.7 35.3) "L28_VIA030_C060")
  hiBindExistingVia(f "VBAT_C17_APP" "GND" list(48.9 32.4) "L28_VIA030_C060")
  hiProof(f "U1.5" "Y1.1" t)
  hiProof(f "Y1.1" "C22.1" t)
  hiProof(f "U1.6" "R31.1" t)
  hiProof(f "R31.2" "Y1.3" t)
  hiProof(f "R31.2" "C23.1" t)
  hiProof(f "C22.2" "HSE_LOCAL_C22" t)
  hiProof(f "C23.2" "HSE_LOCAL_C23" t)
  hiProof(f "Y1.4" "HSE_CASE_APP" t)
  hiProof(f "Y1.2" "HSE_CASE_APP" t)
  hiProof(f "U1.9" "C18.1" t)
  hiProof(f "C18.1" "C19.1" t)
  hiProof(f "C19.1" "C20.1" t)
  hiProof(f "C20.1" "R26.2" t)
  hiProof(f "U1.8" "VSSA8_APP" t)
  hiProof(f "C18.2" "C18_APP_GND" t)
  hiProof(f "C19.2" "C19_APP_GND" t)
  hiProof(f "C20.2" "C20_APP_GND" t)
  hiProof(f "C24.2" "C24_APP_GND" t)
  hiProof(f "C21.2" "C21_APP_GND" t)
  hiProof(f "U1.10" "C24.1" t)
  hiProof(f "C24.1" "R32.2" t)
  hiProof(f "R32.1" "J10.1" t)
  hiProof(f "U1.7" "C21.1" t)
  hiProof(f "C21.1" "NRST_SERVICE" t)
  hiProof(f "U1.1" "C17.1" t)
  hiProof(f "C17.2" "VBAT_C17_APP" t)
  hiProof(f "C22.2" "HI_HSE_QUIET" t)
  hiProof(f "C23.2" "HI_HSE_QUIET" t)
  hiProof(f "HI_GUARD_LEFT_END" "C23.2" t)
  hiProof(f "HI_GUARD_RIGHT_END" "C22.2" t)
  hiProof(f "HI_GUARD_RIGHT_LOWER_END" "C22.2" t)
  hiProof(f "C22.2" "U1.47" t)
  hiHSEIsolationChallenge("D:/001DIY/005lib/01AIEDA/learning/examples/lessonHI_38_50_20261021/logs/reopen_mcu_2L_b006" list(45.45 28.85) "BOTTOM" list(list(42.2 39.8) list(44.2 39.8) list(47.8 33.5)))
  fprintf(f "HI_REOPEN_ALL_ENDPOINTS_COMPLETE\n") close(f) t))
