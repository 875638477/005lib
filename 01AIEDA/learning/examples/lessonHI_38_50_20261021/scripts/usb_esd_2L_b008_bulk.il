procedure(hiBatchProgram()
 let((f)
  f=outfile("D:/001DIY/005lib/01AIEDA/learning/examples/lessonHI_38_50_20261021/logs/usb_esd_2L_b008_bulk/hi_batch_execution.txt")
  fprintf(f "HI_BATCH_DRC_BEFORE=%L\n" axlDBControl('drcEnable))
  unwindProtect(
   progn(
    axlDBControl('drcEnable nil)
    fprintf(f "HI_ASSEMBLY_ONLINE_DRC_TEMPORARILY_DISABLED=%L\n" axlDBControl('drcEnable))
    hiRegistry=nil
    hiNodeDefinitions=list(list("USB_DP_MIRROR_A" "USB_DP" "TOP" list(39.75 5.8) "via") list("USB_DP_MIRROR_B" "USB_DP" "TOP" list(40.75 5.8) "via") list("USB_DP_A6_TO_MIRROR" "USB_DP" "TOP" list(39.75 7.355) "point") list("USB_DP_B6_TO_MIRROR" "USB_DP" "TOP" list(40.75 7.355) "point") list("USB_DP_MIRROR_BOTTOM" "USB_DP" "BOTTOM" list(39.75 5.8) "point") list("USB_DM_A7_MERGE" "USB_DM" "TOP" list(40.25 7.355) "point") list("USB_DP_ENTRY" "USB_DP" "TOP" list(40.75 7.355) "point") list("USB_DM_ENTRY" "USB_DM" "TOP" list(39.25 7.355) "point") list("USB_SHARED_DP" "PA12_SHARED" "TOP" list(41.1 18.3984) "point") list("USB_DNP_STUB_DP" "PA12_SHARED" "TOP" list(41.1 18.3984) "point") list("USB_DNP_STUB_DM" "PA11_SHARED" "TOP" list(39.4 18.3984) "point") list("USB_RETURN_LEFT" "GND" "TOP" list(38.15 5.8) "via") list("USB_RETURN_RIGHT" "GND" "TOP" list(41.7 5.8) "via") list("USB_U4_DP_FLOW" "USB_DP" "TOP" list(41.2 10.1) "point") list("USB_U4_DM_FLOW" "USB_DM" "TOP" list(39.3 10.1) "point") list("USB2L_DP_PORT1" "USB_DP" "TOP" list(41.2 12.7) "point") list("USB2L_DM_PORT1" "USB_DM" "TOP" list(39.3 12.7) "point") list("USB2L_DP_WIDE" "USB_DP" "TOP" list(40.905 14.2) "point") list("USB2L_DM_WIDE" "USB_DM" "TOP" list(39.595 14.2) "point") list("USB_PULLUP_BRANCH" "USB_DP" "TOP" list(40.905 14.6) "point") list("USB_SHARED_DM" "PA11_SHARED" "TOP" list(39.4 18.3984) "point") list("ESD_U4_RETURN" "GND" "TOP" list(40.25 12.7) "point") list("V_HI_ESD_A" "GND" "TOP" list(40.0 11.4) "via") list("ESD_U4_SECOND_VIA" "GND" "TOP" list(40.25 11.8) "point") list("V_HI_ESD_B" "GND" "TOP" list(40.5 11.6) "via") list("ESD_C10_RETURN" "GND" "TOP" list(42.7 10.7764) "point") list("V_HI_C10_A" "GND" "TOP" list(43.8 10.7764) "via") list("V_HI_C10_B" "GND" "TOP" list(43.8 11.5764) "via") list("ESD_VBUS_U4_ESCAPE" "USB_VBUS" "TOP" list(40.25 10.1) "point") list("V_HI_ESD_VBUS_LEFT" "USB_VBUS" "TOP" list(40.25 9.3) "via") list("ESD_VBUS_BOTTOM_BRIDGE" "USB_VBUS" "BOTTOM" list(40.25 9.3) "point") list("V_HI_C10_VBUS" "USB_VBUS" "TOP" list(43.8 9.2016) "via") list("ESD_VBUS_C10" "USB_VBUS" "TOP" list(43.8 9.2016) "point") list("USB_DP_TRUNK_NODE" "USB_DP" "TOP" list(40.905 14.6) "point"))
    hiMove(f "U4" list(40.25 11.4) 180.0)
    hiMove(f "R5" list(41.1 18.5) 270.0)
    hiMove(f "R12" list(42.8 18.3) 0.0)
    hiMove(f "R13" list(38.0 18.3) 180.0)
    hiMove(f "R11" list(42.9764 14.6) 180.0)
    hiAssignNetClass(f "HI_USB_DP_P_2L" 'physical "HI2L_P_USB_FS" list("USB_DP"))
    hiCSet(f 'physical "HI_USB_MIRROR_P_2L" "HI2L_P_USB_FS" list())
    hiCSetLayerValue(f 'physical "HI_USB_MIRROR_P_2L" "BOTTOM" 'allow_etch t)
    hiRegion(f "HI_J2_MIRROR_BOTTOM" "BOTTOM" list(list(39.35 5.3) list(41.15 5.3) list(41.15 6.7) list(39.35 6.7)) list(list("HI_USB_DP_P_2L" 'physical "HI_USB_MIRROR_P_2L" nil)))
    hiECSetCopy(f "HI_E_USB_CONNECTOR_2L" "HI2L_E_USB_BUDGET" list(list('Differential_Pair_Phase_Tolerance "4 MM") list('Differential_Pair_Max_Uncoupled_Length "13.5 MM")) "DP_USB_CONNECTOR")
    hiCSet(f 'spacing "HI_USB_J2_SOURCE_S_2L" "HI2L_S_CLASSCLASS_10" list(list('smdpin_line "0.2 MM")))
    hiRegion(f "HI_USB_J2_SOURCE_ESCAPE" "TOP" list(list(38.95 7.25) list(39.55 7.25) list(39.55 8.55) list(38.95 8.55)) list(list("HI2L_USB_FS_S" 'spacing "HI_USB_J2_SOURCE_S_2L" "HI2L_USB_AUX_S")))
    hiCSet(f 'spacing "HI_USB_MCU_S_1_2L" "HI2L_S_CLASSCLASS_8" list(list('smdpin_line "0.2 MM") list('line_line "0.2 MM")))
    hiCSet(f 'spacing "HI_USB_MCU_S_2_2L" "HI2L_S_CLASSCLASS_6" list(list('smdpin_line "0.2 MM") list('line_line "0.2 MM")))
    hiRegion(f "HI_USB_MCU_ESCAPE" "TOP" list(list(39.8 21.2) list(41.6 21.2) list(41.6 23.4) list(39.8 23.4)) list(list("HI2L_USB_FS_S" 'spacing "HI_USB_MCU_S_1_2L" "HI2L_UART_CAN_DIGITAL_S") list("HI2L_USB_FS_S" 'spacing "HI_USB_MCU_S_2_2L" "HI2L_RESET_BOOT_SWD_S")))
    hiVia(f "USB_DP_MIRROR_A" "USB_DP" list(39.75 5.8) "L28_VIA030_C060")
    hiVia(f "USB_DP_MIRROR_B" "USB_DP" list(40.75 5.8) "L28_VIA030_C060")
    hiRoute(f "USB_DP_A6_TO_MIRROR" "USB_DP" "TOP" list(list(39.75 7.355) list(39.75 5.8)) list(0.2))
    hiRoute(f "USB_DP_B6_TO_MIRROR" "USB_DP" "TOP" list(list(40.75 7.355) list(40.75 5.8)) list(0.2))
    hiRoute(f "USB_DP_MIRROR_BOTTOM" "USB_DP" "BOTTOM" list(list(39.75 5.8) list(40.75 5.8)) list(0.2))
    hiRoute(f "USB_DM_A7_MERGE" "USB_DM" "TOP" list(list(40.25 7.355) list(40.25 8.6) list(39.25 8.6) list(39.25 7.355)) list(0.2 0.2 0.2))
    hiRoute(f "USB_DP_ENTRY" "USB_DP" "TOP" list(list(40.75 7.355) list(40.75 8.6) list(41.2 9.05) list(41.2 10.1)) list(0.2 0.2 0.2))
    hiRoute(f "USB_DM_ENTRY" "USB_DM" "TOP" list(list(39.25 7.355) list(39.25 8.6) list(39.3 8.65) list(39.3 10.1)) list(0.2 0.2 0.2))
    hiRoute(f "USB_SHARED_DP" "PA12_SHARED" "TOP" list(list(41.1 18.3984) list(41.1 19.85) list(40.95 20.0) list(40.95 21.6) list(41.25 21.9) list(41.25 22.75)) list(0.2 0.2 0.2 0.2 0.2))
    hiRoute(f "USB_DNP_STUB_DP" "PA12_SHARED" "TOP" list(list(41.1 18.3984) list(42.8032 18.3984) list(42.9016 18.3)) list(0.2 0.2))
    hiRoute(f "USB_DNP_STUB_DM" "PA11_SHARED" "TOP" list(list(39.4 18.3984) list(37.9968 18.3984) list(37.8984 18.3)) list(0.2 0.2))
    hiVia(f "USB_RETURN_LEFT" "GND" list(38.15 5.8) "L28_VIA030_C060")
    hiVia(f "USB_RETURN_RIGHT" "GND" list(41.7 5.8) "L28_VIA030_C060")
    hiRoute(f "USB_U4_DP_FLOW" "USB_DP" "TOP" list(list(41.2 10.1) list(41.2 12.7)) list(0.2))
    hiRoute(f "USB_U4_DM_FLOW" "USB_DM" "TOP" list(list(39.3 10.1) list(39.3 12.7)) list(0.2))
    hiRoute(f "USB2L_DP_PORT1" "USB_DP" "TOP" list(list(41.2 12.7) list(41.2 13.905) list(40.905 14.2)) list(0.2 0.2))
    hiRoute(f "USB2L_DM_PORT1" "USB_DM" "TOP" list(list(39.3 12.7) list(39.3 13.905) list(39.595 14.2)) list(0.2 0.2))
    hiRoute(f "USB2L_DP_WIDE" "USB_DP" "TOP" list(list(40.905 14.2) list(40.905 16.6286) list(41.1 16.8236)) list(1.15 1.15))
    hiRoute(f "USB2L_DM_WIDE" "USB_DM" "TOP" list(list(39.595 14.2) list(39.595 16.6286) list(39.4 16.8236)) list(1.15 1.15))
    hiRoute(f "USB_PULLUP_BRANCH" "USB_DP" "TOP" list(list(40.905 14.6) list(41.3 14.6)) list(0.2))
    hiRoute(f "USB_SHARED_DM" "PA11_SHARED" "TOP" list(list(39.4 18.3984) list(39.4 18.95) list(40.59 20.14) list(40.59 21.7492) list(40.75 21.9092) list(40.75 22.75)) list(0.2 0.2 0.2 0.2 0.2))
    hiRoute(f "ESD_U4_RETURN" "GND" "TOP" list(list(40.25 12.7) list(40.25 11.8) list(40.0 11.4)) list(0.6 0.6))
    hiVia(f "V_HI_ESD_A" "GND" list(40.0 11.4) "L28_VIA030_C060")
    hiRoute(f "ESD_U4_SECOND_VIA" "GND" "TOP" list(list(40.25 11.8) list(40.5 11.6)) list(0.6))
    hiVia(f "V_HI_ESD_B" "GND" list(40.5 11.6) "L28_VIA030_C060")
    hiRoute(f "ESD_C10_RETURN" "GND" "TOP" list(list(42.7 10.7764) list(43.8 10.7764) list(43.8 11.5764)) list(0.6 0.6))
    hiVia(f "V_HI_C10_A" "GND" list(43.8 10.7764) "L28_VIA030_C060")
    hiVia(f "V_HI_C10_B" "GND" list(43.8 11.5764) "L28_VIA030_C060")
    hiRoute(f "ESD_VBUS_U4_ESCAPE" "USB_VBUS" "TOP" list(list(40.25 10.1) list(40.25 9.3)) list(0.4))
    hiVia(f "V_HI_ESD_VBUS_LEFT" "USB_VBUS" list(40.25 9.3) "L28_VIA030_C060")
    hiRoute(f "ESD_VBUS_BOTTOM_BRIDGE" "USB_VBUS" "BOTTOM" list(list(40.25 9.3) list(43.8 9.2016)) list(0.6))
    hiVia(f "V_HI_C10_VBUS" "USB_VBUS" list(43.8 9.2016) "L28_VIA030_C060")
    hiRoute(f "ESD_VBUS_C10" "USB_VBUS" "TOP" list(list(43.8 9.2016) list(42.7 9.2016)) list(0.6))
    hiShape(f "HI_USB_TOP_REFERENCE" "GND" "TOP" list(list(37.7 4.3) list(42.2 4.3) list(42.2 6.6) list(37.7 6.6)) t list())
    hiHSEIsolationChallengeGraph("D:/001DIY/005lib/01AIEDA/learning/examples/lessonHI_38_50_20261021/logs/usb_esd_2L_b008_bulk" list(45.45 28.85) "BOTTOM" list(list(42.2 39.8) list(44.2 39.8) list(47.8 33.5)))
    t)
   progn(
    axlDBControl('drcEnable t)
    fprintf(f "HI_UNWIND_DRC_RESTORED=%L\n" axlDBControl('drcEnable))))
  unless(axlDBControl('drcEnable) error("Final DRC must be enabled\n"))
  hiFinalize(f "D:/001DIY/005lib/01AIEDA/learning/examples/lessonHI_38_50_20261021/logs/usb_esd_2L_b008_bulk" "D:/001DIY/005lib/01AIEDA/learning/examples/lessonHI_38_50_20261021/native/HI_2L_usb_esd_2L_b008_bulk.brd" "D:/001DIY/005lib/01AIEDA/learning/examples/lessonHI_38_50_20261021/library" list(list("J2.A6" "USB_DP_MIRROR_A" t) list("J2.B6" "USB_DP_MIRROR_B" t) list("USB_DP_MIRROR_A" "USB_DP_MIRROR_B" t) list("J2.A7" "J2.B7" t) list("J2.B6" "U4.6" t) list("J2.B7" "U4.4" t) list("R5.1" "U1.33" t) list("R5.1" "R12.1" t) list("R6.1" "R13.1" t) list("U4.6" "U4.1" t) list("U4.4" "U4.3" t) list("USB_DP_TRUNK_NODE" "R11.2" t) list("R6.1" "U1.32" t) list("U4.2" "V_HI_ESD_A" t) list("ESD_U4_RETURN" "V_HI_ESD_B" t) list("C10.2" "V_HI_C10_B" t) list("U4.5" "V_HI_ESD_VBUS_LEFT" t) list("V_HI_ESD_VBUS_LEFT" "V_HI_C10_VBUS" t) list("V_HI_C10_VBUS" "C10.1" t) list("J2.A6" "U4.6" t) list("J2.B6" "U4.6" t) list("J2.A7" "U4.4" t) list("J2.B7" "U4.4" t) list("U4.1" "R5.2" t) list("U4.3" "R6.2" t) list("R11.2" "R5.2" t) list("R5.1" "U1.33" t) list("R6.1" "U1.32" t) list("U4.2" "U1.47" t) list("C10.2" "U1.47" t) list("USB_RETURN_LEFT" "HI_USB_TOP_REFERENCE" t) list("USB_RETURN_RIGHT" "HI_USB_TOP_REFERENCE" t)))
  t))
