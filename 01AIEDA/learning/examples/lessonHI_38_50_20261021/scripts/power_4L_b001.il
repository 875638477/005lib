procedure(hiBatchProgram()
 let((f)
  f=outfile("D:/001DIY/005lib/01AIEDA/learning/examples/lessonHI_38_50_20261021/logs/power_4L_b001/hi_batch_execution.txt")
  hiRegistry=nil
  hiMove(f "C3" list(26.2 18.0) 180.0)
  hiCSet(f 'physical "HI_U2_SW_ESCAPE_P" "P_SWITCH_060" list(list('necklength_max "1.2 MM")))
  hiRegion(f "HI_U2_SW_ESCAPE" "TOP" list(list(22.95 20.55) list(24.9 20.55) list(24.9 21.45) list(22.95 21.45)) list(list("NC_SWITCHING_P" 'physical "HI_U2_SW_ESCAPE_P")))
  hiRoute(f "VIN_U2_ESCAPE" "VIN_PROT" "TOP" list(list(24.2 20.05) list(24.2 19.1) list(26.0984 19.1) list(26.0984 18.0)) list(0.25 0.6 0.6))
  hiRoute(f "VIN_C2_C3" "VIN_PROT" "TOP" list(list(25.2 15.4) list(26.0984 18.0)) list(0.6))
  hiRoute(f "SW_U2_L1" "BUCK_SW" "TOP" list(list(24.2 21.0) list(23.05 21.0) list(22.6 21.0) list(22.02 21.58) list(22.02 24.0)) list(0.25 0.6 0.6 0.6))
  hiRoute(f "BOOT_U2_C4" "BUCK_BOOT" "TOP" list(list(26.8 21.95) list(26.8 22.55) list(26.5984 22.7516) list(26.5984 23.7)) list(0.25 0.6 0.6))
  hiRoute(f "SW_C4_L1" "BUCK_SW" "TOP" list(list(25.0236 23.7) list(25.0236 24.6) list(22.02 24.6) list(22.02 24.0)) list(0.6 0.6 0.6))
  hiRoute(f "C3_GND_VIAS" "GND" "TOP" list(list(24.5236 18.0) list(23.2 18.0) list(23.2 18.8)) list(0.6 0.6))
  hiRoute(f "U2_GND_VIAS" "GND" "TOP" list(list(24.2 21.95) list(24.2 22.55) list(23.7 22.55) list(23.7 23.35)) list(0.25 0.6 0.6))
  hiRoute(f "C2_GND_VIAS" "GND" "TOP" list(list(22.152 15.4) list(22.152 14.25) list(22.152 13.45)) list(0.6 0.6))
  hiVia(f "V_HI_C3_A" "GND" list(23.2 18.0) "L28_VIA030_C060")
  hiVia(f "V_HI_C3_B" "GND" list(23.2 18.8) "L28_VIA030_C060")
  hiVia(f "V_HI_U2_A" "GND" list(23.7 22.55) "L28_VIA030_C060")
  hiVia(f "V_HI_U2_B" "GND" list(23.7 23.35) "L28_VIA030_C060")
  hiVia(f "V_HI_C2_A" "GND" list(22.152 14.25) "L28_VIA030_C060")
  hiVia(f "V_HI_C2_B" "GND" list(22.152 13.45) "L28_VIA030_C060")
  hiFinalize(f "D:/001DIY/005lib/01AIEDA/learning/examples/lessonHI_38_50_20261021/logs/power_4L_b001" "D:/001DIY/005lib/01AIEDA/learning/examples/lessonHI_38_50_20261021/native/HI_4L_power_4L_b001.brd" "D:/001DIY/005lib/01AIEDA/learning/examples/lessonHI_38_50_20261021/library" list(list("U2.3" "C3.1" t) list("C2.1" "C3.1" t) list("U2.2" "L1.1" t) list("U2.6" "C4.1" t) list("C4.2" "L1.1" t) list("C3.2" "V_HI_C3_B" t) list("U2.1" "V_HI_U2_B" t) list("C2.2" "V_HI_C2_B" t)))
  t))
