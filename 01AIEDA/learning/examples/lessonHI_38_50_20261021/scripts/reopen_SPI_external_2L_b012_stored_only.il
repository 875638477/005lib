procedure(hiGroundPointCheckReadOnly(f id xy topConnected bottomConnected)
 let((graph shapes expected actual)
  graph=gConnectedObjects(gPin("U1" "23"))
  foreach(layer list("TOP" "BOTTOM")
   expected=if(equal(layer "TOP") then topConnected else bottomConnected)
   shapes=setof(s axlDBGetShapes(strcat("ETCH/" layer)) s->fill && s->net && equal(s->net->name "GND") && !s->shapeIsBoundary && axlGeoPointInShape(xy s t))
   unless(length(shapes)==1 error("Ground stitch point must be inside exactly one actual filled GND shape on each layer, layer=%L shapes=%L\n" layer shapes))
   unless(car(shapes)->shapeBoundary error("Ground stitch point must be in application dynamic copper, not static quiet island\n"))
   actual=if(member(car(shapes) graph) then t else nil)
   fprintf(f "HI_GROUND_POINT_CHECK id=%L layer=%L xy=%L bbox=%L globalPin=U1.23 expectedConnected=%L actualConnected=%L shapeAttrs=%L\n" id layer xy car(shapes)->bBox expected actual car(shapes)->??)
   unless(equal(expected actual) error("Application ground shape connectivity does not match intended stitch pre/post condition\n")))
  t))

; Instrument exact unchanged all-on-plus-batch DRC request and result.
procedure(hiStoredReadback()
 let((f)
 f=outfile("D:/001DIY/005lib/01AIEDA/learning/examples/lessonHI_38_50_20261021/logs/reopen_SPI_external_2L_b012_stored_only/hi_reopen_endpoint_proofs.txt")
 hiRegistry=nil hiNodeDefinitions=list(list("SPI_PREFILTER_ROW_SHIFT" "V3V3" "TOP" list(29.8 30.95) "point") list("SPI_SCK_EAST" "SPI_SCK" "TOP" list(30.8 29.95) "via") list("SPI_SCK_WEST" "SPI_SCK" "TOP" list(21.85 29.95) "via") list("SPI_SCK_EAST_TOP" "SPI_SCK" "TOP" list(32.0252 31.0) "point") list("SPI_SCK_BOTTOM_BRIDGE" "SPI_SCK" "BOTTOM" list(30.8 29.95) "point") list("SPI_SCK_WEST_TOP" "SPI_SCK" "TOP" list(21.85 29.95) "point") list("SPI_MOSI_EAST" "SPI_MOSI" "TOP" list(31.65 27.8) "via") list("SPI_MOSI_WEST" "SPI_MOSI" "TOP" list(14.0 29.3) "via") list("SPI_MOSI_EAST_TOP" "SPI_MOSI" "TOP" list(32.0252 27.0) "point") list("SPI_MOSI_BOTTOM_BRIDGE" "SPI_MOSI" "BOTTOM" list(31.65 27.8) "point") list("SPI_MOSI_WEST_TOP" "SPI_MOSI" "TOP" list(14.0 29.3) "point") list("SPI_MISO_EAST" "SPI_MISO" "TOP" list(31.65 29.77) "via") list("SPI_MISO_WEST" "SPI_MISO" "TOP" list(20.5 30.8) "via") list("SPI_MISO_EAST_TOP" "SPI_MISO" "TOP" list(32.0252 29.0) "point") list("SPI_MISO_BOTTOM_BRIDGE" "SPI_MISO" "BOTTOM" list(31.65 29.77) "point") list("SPI_MISO_WEST_TOP" "SPI_MISO" "TOP" list(20.5 30.8) "point") list("SPI_NSS_EAST" "SPI_NSS" "TOP" list(29.6 32.46) "via") list("SPI_NSS_WEST" "SPI_NSS" "TOP" list(20.3 32.4) "via") list("SPI_NSS_EAST_TOP" "SPI_NSS" "TOP" list(31.2236 33.02) "point") list("SPI_NSS_BOTTOM_BRIDGE" "SPI_NSS" "BOTTOM" list(29.6 32.46) "point") list("SPI_NSS_WEST_TOP" "SPI_NSS" "TOP" list(20.3 32.4) "point") list("SPI_RETURN_SCK_E" "GND" "TOP" list(30.9 29.1) "via") list("SPI_RETURN_SCK_W" "GND" "TOP" list(20.5 29.32) "via") list("SPI_RETURN_MOSI_E" "GND" "TOP" list(32.8 25.3) "via") list("SPI_RETURN_MOSI_W" "GND" "TOP" list(14.0 30.6) "via") list("SPI_RETURN_MISO_E" "GND" "TOP" list(32.85 28.1) "via") list("SPI_RETURN_GUARD_E" "GND" "TOP" list(27.1 31.55) "via") list("SPI_RETURN_GUARD_W" "GND" "TOP" list(21.0 31.55) "via") list("SPI_RETURN_NSS_E" "GND" "TOP" list(29.0 33.2) "via") list("SPI_RETURN_NSS_W" "GND" "TOP" list(20.8 33.75) "via") list("SPI_GUARD_CLOCK_MOSI" "GND" "BOTTOM" list(28.6 29.0) "point") list("SPI_GUARD_MISO_NSS" "GND" "BOTTOM" list(29.9 31.55) "point"))
 hiBindExistingVia(f "SPI_SCK_EAST" "SPI_SCK" list(30.8 29.95) "L28_VIA030_C060")
 hiBindExistingVia(f "SPI_SCK_WEST" "SPI_SCK" list(21.85 29.95) "L28_VIA030_C060")
 hiBindExistingVia(f "SPI_MOSI_EAST" "SPI_MOSI" list(31.65 27.8) "L28_VIA030_C060")
 hiBindExistingVia(f "SPI_MOSI_WEST" "SPI_MOSI" list(14.0 29.3) "L28_VIA030_C060")
 hiBindExistingVia(f "SPI_MISO_EAST" "SPI_MISO" list(31.65 29.77) "L28_VIA030_C060")
 hiBindExistingVia(f "SPI_MISO_WEST" "SPI_MISO" list(20.5 30.8) "L28_VIA030_C060")
 hiBindExistingVia(f "SPI_NSS_EAST" "SPI_NSS" list(29.6 32.46) "L28_VIA030_C060")
 hiBindExistingVia(f "SPI_NSS_WEST" "SPI_NSS" list(20.3 32.4) "L28_VIA030_C060")
 hiBindExistingVia(f "SPI_RETURN_SCK_E" "GND" list(30.9 29.1) "L28_VIA030_C060")
 hiBindExistingVia(f "SPI_RETURN_SCK_W" "GND" list(20.5 29.32) "L28_VIA030_C060")
 hiBindExistingVia(f "SPI_RETURN_MOSI_E" "GND" list(32.8 25.3) "L28_VIA030_C060")
 hiBindExistingVia(f "SPI_RETURN_MOSI_W" "GND" list(14.0 30.6) "L28_VIA030_C060")
 hiBindExistingVia(f "SPI_RETURN_MISO_E" "GND" list(32.85 28.1) "L28_VIA030_C060")
 hiBindExistingVia(f "SPI_RETURN_GUARD_E" "GND" list(27.1 31.55) "L28_VIA030_C060")
 hiBindExistingVia(f "SPI_RETURN_GUARD_W" "GND" list(21.0 31.55) "L28_VIA030_C060")
 hiBindExistingVia(f "SPI_RETURN_NSS_E" "GND" list(29.0 33.2) "L28_VIA030_C060")
 hiBindExistingVia(f "SPI_RETURN_NSS_W" "GND" list(20.8 33.75) "L28_VIA030_C060")
 hiProof(f "R21.2" "J6.2" t)
 hiProof(f "R22.2" "J6.3" t)
 hiProof(f "R24.2" "J6.4" t)
 hiProof(f "R23.2" "J6.5" t)
 hiProof(f "SPI_RETURN_SCK_E" "U1.23" t)
 hiProof(f "SPI_RETURN_SCK_W" "U1.23" t)
 hiProof(f "SPI_RETURN_MOSI_E" "U1.23" t)
 hiProof(f "SPI_RETURN_MOSI_W" "U1.23" t)
 hiProof(f "SPI_RETURN_MISO_E" "U1.23" t)
 hiProof(f "SPI_RETURN_GUARD_E" "U1.23" t)
 hiProof(f "SPI_RETURN_GUARD_W" "U1.23" t)
 hiProof(f "SPI_RETURN_NSS_E" "U1.23" t)
 hiProof(f "SPI_RETURN_NSS_W" "U1.23" t)
 hiProof(f "SPI_GUARD_CLOCK_MOSI" "U1.23" t)
 hiProof(f "SPI_GUARD_MISO_NSS" "U1.23" t)
 hiProof(f "C9.1" "SPI_PREFILTER_ROW_SHIFT" t)
 fprintf(f "HI_REOPEN_ALL_ENDPOINTS_COMPLETE_STORED_STATE_ONLY_NO_DRC_RECOMPUTE\n") close(f)
 f=outfile("D:/001DIY/005lib/01AIEDA/learning/examples/lessonHI_38_50_20261021/logs/reopen_SPI_external_2L_b012_stored_only/hi_readback_scope.txt")
 fprintf(f "READBACK_SCOPE=FRESH_STORED_STATE_GEOMETRY_CONNECTIVITY_ONLY\nFULL_DRC_RECOMPUTE=NOT_REQUESTED_IN_THIS_READBACK\nFINAL_WHOLE_BOARD_DRC_PENDING=t\nHSE_NEGATIVE_NOT_REPEATED_HERE_BUILD_EVIDENCE_REMAINS\nDRC_ENABLE=%L\nSTORED_DRC_COUNT=%d\nPHYSICAL_MODES=%L\nSPACING_MODES=%L\nELECTRICAL_MODES=%L\n" axlDBControl('drcEnable) length(axlDBGetDesign()->drcs) axlCNSPhysicalModeGet('all) axlCNSSpacingModeGet('all) axlCNSEcsetModeGet('all)) close(f) t))
