procedure(hiInspectPrivatePad(out lib)
 let((f ps pad layers)
  f=outfile(strcat(out "/private_pad_definition.txt"))
  axlSetVariable("padpath" list(lib))
  ps=axlLoadPadstack("HI_VIA026_C052_TENT")
  unless(ps error("Private padstack failed to load\n"))
  fprintf(f "PAD_DEFINITION=%L\nACTUAL_ROUTE_LAYERS=%L\n" ps->?? axlSubclassRoute())
  unless(abs(ps->drillDiameter-0.26)<0.00001 && equal(ps->usage "Through_via") error("Unexpected drill/usage\n"))
  layers=append(mapcar(lambda((x) strcat("ETCH/" x)) axlSubclassRoute()) list('internal "VIA CLASS/SOLDERMASK_TOP" "VIA CLASS/SOLDERMASK_BOTTOM"))
  foreach(layer layers
   foreach(kind list("REGULAR" "ANTI" "THERMAL" "KEEPOUT")
    pad=axlDBGetPad(ps layer kind)
    fprintf(f "PAD_LAYER layer=%L type=%L figure=%L bbox=%L attrs=%L\n" layer kind if(pad then pad->figureName else nil) if(pad then pad->bBox else nil) if(pad then pad->?? else nil))))
  fprintf(f "PRIVATE_PAD_DEFINITION_READ_COMPLETE_NO_SAVE_NO_PLACEMENT_NO_DRC_RECOMPUTE\n") close(f) t))
