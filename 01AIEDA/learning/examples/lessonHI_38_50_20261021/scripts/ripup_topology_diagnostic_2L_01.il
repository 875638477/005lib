procedure(hiRipupDiagnostic()
 let((f mark)
 f=outfile("D:/001DIY/005lib/01AIEDA/learning/examples/lessonHI_38_50_20261021/logs/ripup_topology_diagnostic_2L_01/diagnostic.txt")
 mark=axlDBTransactionStart()
 unwindProtect(
 progn(
 axlDBControl('drcEnable nil)
 fprintf(f "BEFORE\n")
 hiRouteRoles("D:/001DIY/005lib/01AIEDA/learning/examples/lessonHI_38_50_20261021/review/ripup_diagnostic_before")
 hiDeleteVia(f "NSS01_DEL_VIA_[39, 26.2]" "PA4_SPI_NSS" list(39 26.2) "L28_VIA030_C060")
 hiDeleteVia(f "NSS01_DEL_VIA_[32.2, 22]" "PA4_SPI_NSS" list(32.2 22) "L28_VIA030_C060")
 hiDeleteVia(f "OLD_PC14" "GPIO_PC14" list(45.6 25.2) "L28_VIA030_C060")
 hiDeleteVia(f "OLD_PC14_GND" "GND" list(46.95 24.9) "L28_VIA030_C060")
 hiDeleteVia(f "OLD_HSE_ANCHOR" "GND" list(45.45 28.85) "L28_VIA030_C060")
 hiDeleteVia(f "OLD_C15_COMMON_GND" "GND" list(47.45 28.7252) "L28_VIA030_C060")
 hiDeleteSegment(f "GPIO_NORTH_RIP_PC15_VERTICAL" "GPIO_PC15" "BOTTOM" list(list(40.3 28.9) list(40.3 30.3)) 0.2)
 fprintf(f "AFTER_FIRST_TARGET_DELETE\n")
 hiRouteRoles("D:/001DIY/005lib/01AIEDA/learning/examples/lessonHI_38_50_20261021/review/ripup_diagnostic_after")
 foreach(o axlExtractMap("C:/Program0/Cadence/SPB172/share/pcb/text/views/fgeo_bv.txt" nil)
 when(equal(o->objType "line") && equal(o->layer "ETCH/BOTTOM") && o->startEnd && (equal(o->startEnd list(list(40.3 30.3) list(35.4 30.3))) || equal(reverse(o->startEnd) list(list(40.3 30.3) list(35.4 30.3))))
 fprintf(f "REMAINING_TARGET actual=%L parent=%L\n" o->?? o->parent->??)))
 t)
 progn(axlDBTransactionRollback(mark) axlDBRefreshId(nil) axlDBControl('drcEnable t)))
 fprintf(f "DIAGNOSTIC_COMPLETE_NO_SAVE_ROLLBACK_DRC_RESTORED=%L\n" axlDBControl('drcEnable))
 close(f) t))
