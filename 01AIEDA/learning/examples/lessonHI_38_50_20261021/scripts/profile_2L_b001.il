procedure(hi2LProfile(out board lib)
 let((f oldRegion oldTables nc old net pair)
  f=outfile(strcat(out "/hi_2L_profile_execution.txt"))
  hiRegistry=nil
  unless(equal(axlSubclassRoute() list("TOP" "BOTTOM")) error("2L profile on wrong board\n"))
  oldRegion=car(setof(r axlDBGetDesign()->region equal(r->name "G31_U1_ESCAPE")))
  unless(oldRegion error("Original G31 region missing\n"))
  oldTables=axlCnsClassTableFind('match oldRegion)
  fprintf(f "OLD_G31_TABLES_REMOVED=%L\n" oldTables)
  when(oldTables unless(axlCnsClassTableDelete(oldTables) error("Cannot remove old G31 region associations\n")))
  unless(axlCNSCreate('physical "HI2L_P_POWER_INPUT" nil) error("Cannot create2L physical CSet\n"))
  f29Must(axlCNSSetPhysical("HI2L_P_POWER_INPUT" nil 'width_min "0.6 MM") "2L specific physical value")
  f29Must(axlCNSSetPhysical("HI2L_P_POWER_INPUT" nil 'neckwidth_min "0.25 MM") "2L specific physical value")
  f29Must(axlCNSSetPhysical("HI2L_P_POWER_INPUT" nil 'necklength_max "1.0 MM") "2L specific physical value")
  f29Must(axlCNSSetPhysical("HI2L_P_POWER_INPUT" nil 'vias "L28_VIA030_C060") "Approved2L via")
  f29Must(axlCNSSetPhysical("HI2L_P_POWER_INPUT" "TOP" 'allow_etch t) "2L layer permission")
  f29Must(axlCNSSetPhysical("HI2L_P_POWER_INPUT" "BOTTOM" 'allow_etch t) "2L layer permission")
  unless(axlCNSCreate('spacing "HI2L_S_POWER_INPUT" nil) error("Cannot create2L spacing CSet\n"))
  f29Must(axlCNSSetSpacing("HI2L_S_POWER_INPUT" nil 'smdpin_line "0.3 MM") "2L explicit spacing value")
  f29Must(axlCNSSetSpacing("HI2L_S_POWER_INPUT" nil 'line_line "0.3 MM") "2L explicit spacing value")
  f29Must(axlCNSSetSpacing("HI2L_S_POWER_INPUT" nil 'via_line "0.3 MM") "2L explicit spacing value")
  f29Must(axlCNSSetSpacing("HI2L_S_POWER_INPUT" nil 'line_shape "0.3 MM") "2L explicit spacing value")
  f29Must(axlCNSSetSpacing("HI2L_S_POWER_INPUT" nil 'via_shape "0.3 MM") "2L explicit spacing value")
  f29Must(axlCNSSetSpacing("HI2L_S_POWER_INPUT" nil 'shape_shape "0.3 MM") "2L explicit spacing value")
  nc=axlNetClassCreate("HI2L_POWER_INPUT_P" 'physical)
  unless(nc error("2L netclass create failed\n"))
  axlDBAddProp(list(nc) list(list("PHYSICAL_CONSTRAINT_SET" "HI2L_P_POWER_INPUT")))
  net=axlDBFindByName('net "VIN_RAW")
  old=axlNetClassGet(net 'physical t)
  when(old fprintf(f "CLASS_REASSIGN net=%L domain=%L old=%L new=%L\n" "VIN_RAW" 'physical old->name "HI2L_POWER_INPUT_P") unless(axlNetClassRemove(old net) error("Cannot remove prior class membership\n")))
  unless(axlNetClassAdd(nc net) error("Cannot bind2L netclass member\n"))
  net=axlDBFindByName('net "VIN_FUSED")
  old=axlNetClassGet(net 'physical t)
  when(old fprintf(f "CLASS_REASSIGN net=%L domain=%L old=%L new=%L\n" "VIN_FUSED" 'physical old->name "HI2L_POWER_INPUT_P") unless(axlNetClassRemove(old net) error("Cannot remove prior class membership\n")))
  unless(axlNetClassAdd(nc net) error("Cannot bind2L netclass member\n"))
  net=axlDBFindByName('net "VIN_PROT")
  old=axlNetClassGet(net 'physical t)
  when(old fprintf(f "CLASS_REASSIGN net=%L domain=%L old=%L new=%L\n" "VIN_PROT" 'physical old->name "HI2L_POWER_INPUT_P") unless(axlNetClassRemove(old net) error("Cannot remove prior class membership\n")))
  unless(axlNetClassAdd(nc net) error("Cannot bind2L netclass member\n"))
  nc=axlNetClassCreate("HI2L_POWER_INPUT_S" 'spacing)
  unless(nc error("2L netclass create failed\n"))
  axlDBAddProp(list(nc) list(list("SPACING_CONSTRAINT_SET" "HI2L_S_POWER_INPUT")))
  net=axlDBFindByName('net "VIN_RAW")
  old=axlNetClassGet(net 'spacing t)
  when(old fprintf(f "CLASS_REASSIGN net=%L domain=%L old=%L new=%L\n" "VIN_RAW" 'spacing old->name "HI2L_POWER_INPUT_S") unless(axlNetClassRemove(old net) error("Cannot remove prior class membership\n")))
  unless(axlNetClassAdd(nc net) error("Cannot bind2L netclass member\n"))
  net=axlDBFindByName('net "VIN_FUSED")
  old=axlNetClassGet(net 'spacing t)
  when(old fprintf(f "CLASS_REASSIGN net=%L domain=%L old=%L new=%L\n" "VIN_FUSED" 'spacing old->name "HI2L_POWER_INPUT_S") unless(axlNetClassRemove(old net) error("Cannot remove prior class membership\n")))
  unless(axlNetClassAdd(nc net) error("Cannot bind2L netclass member\n"))
  net=axlDBFindByName('net "VIN_PROT")
  old=axlNetClassGet(net 'spacing t)
  when(old fprintf(f "CLASS_REASSIGN net=%L domain=%L old=%L new=%L\n" "VIN_PROT" 'spacing old->name "HI2L_POWER_INPUT_S") unless(axlNetClassRemove(old net) error("Cannot remove prior class membership\n")))
  unless(axlNetClassAdd(nc net) error("Cannot bind2L netclass member\n"))
  nc=axlNetClassCreate("HI2L_POWER_INPUT_E" 'electrical)
  unless(nc error("2L netclass create failed\n"))
  net=axlDBFindByName('net "VIN_RAW")
  old=axlNetClassGet(net 'electrical t)
  when(old fprintf(f "CLASS_REASSIGN net=%L domain=%L old=%L new=%L\n" "VIN_RAW" 'electrical old->name "HI2L_POWER_INPUT_E") unless(axlNetClassRemove(old net) error("Cannot remove prior class membership\n")))
  unless(axlNetClassAdd(nc net) error("Cannot bind2L netclass member\n"))
  net=axlDBFindByName('net "VIN_FUSED")
  old=axlNetClassGet(net 'electrical t)
  when(old fprintf(f "CLASS_REASSIGN net=%L domain=%L old=%L new=%L\n" "VIN_FUSED" 'electrical old->name "HI2L_POWER_INPUT_E") unless(axlNetClassRemove(old net) error("Cannot remove prior class membership\n")))
  unless(axlNetClassAdd(nc net) error("Cannot bind2L netclass member\n"))
  net=axlDBFindByName('net "VIN_PROT")
  old=axlNetClassGet(net 'electrical t)
  when(old fprintf(f "CLASS_REASSIGN net=%L domain=%L old=%L new=%L\n" "VIN_PROT" 'electrical old->name "HI2L_POWER_INPUT_E") unless(axlNetClassRemove(old net) error("Cannot remove prior class membership\n")))
  unless(axlNetClassAdd(nc net) error("Cannot bind2L netclass member\n"))
  unless(axlCNSCreate('physical "HI2L_P_POWER_LV" nil) error("Cannot create2L physical CSet\n"))
  f29Must(axlCNSSetPhysical("HI2L_P_POWER_LV" nil 'width_min "0.6 MM") "2L specific physical value")
  f29Must(axlCNSSetPhysical("HI2L_P_POWER_LV" nil 'neckwidth_min "0.25 MM") "2L specific physical value")
  f29Must(axlCNSSetPhysical("HI2L_P_POWER_LV" nil 'necklength_max "1.0 MM") "2L specific physical value")
  f29Must(axlCNSSetPhysical("HI2L_P_POWER_LV" nil 'vias "L28_VIA030_C060") "Approved2L via")
  f29Must(axlCNSSetPhysical("HI2L_P_POWER_LV" "TOP" 'allow_etch t) "2L layer permission")
  f29Must(axlCNSSetPhysical("HI2L_P_POWER_LV" "BOTTOM" 'allow_etch t) "2L layer permission")
  unless(axlCNSCreate('spacing "HI2L_S_POWER_LV" nil) error("Cannot create2L spacing CSet\n"))
  f29Must(axlCNSSetSpacing("HI2L_S_POWER_LV" nil 'smdpin_line "0.3 MM") "2L explicit spacing value")
  f29Must(axlCNSSetSpacing("HI2L_S_POWER_LV" nil 'line_line "0.3 MM") "2L explicit spacing value")
  f29Must(axlCNSSetSpacing("HI2L_S_POWER_LV" nil 'via_line "0.3 MM") "2L explicit spacing value")
  f29Must(axlCNSSetSpacing("HI2L_S_POWER_LV" nil 'line_shape "0.3 MM") "2L explicit spacing value")
  f29Must(axlCNSSetSpacing("HI2L_S_POWER_LV" nil 'via_shape "0.3 MM") "2L explicit spacing value")
  f29Must(axlCNSSetSpacing("HI2L_S_POWER_LV" nil 'shape_shape "0.3 MM") "2L explicit spacing value")
  nc=axlNetClassCreate("HI2L_POWER_LV_P" 'physical)
  unless(nc error("2L netclass create failed\n"))
  axlDBAddProp(list(nc) list(list("PHYSICAL_CONSTRAINT_SET" "HI2L_P_POWER_LV")))
  net=axlDBFindByName('net "V5")
  old=axlNetClassGet(net 'physical t)
  when(old fprintf(f "CLASS_REASSIGN net=%L domain=%L old=%L new=%L\n" "V5" 'physical old->name "HI2L_POWER_LV_P") unless(axlNetClassRemove(old net) error("Cannot remove prior class membership\n")))
  unless(axlNetClassAdd(nc net) error("Cannot bind2L netclass member\n"))
  net=axlDBFindByName('net "V3V3")
  old=axlNetClassGet(net 'physical t)
  when(old fprintf(f "CLASS_REASSIGN net=%L domain=%L old=%L new=%L\n" "V3V3" 'physical old->name "HI2L_POWER_LV_P") unless(axlNetClassRemove(old net) error("Cannot remove prior class membership\n")))
  unless(axlNetClassAdd(nc net) error("Cannot bind2L netclass member\n"))
  nc=axlNetClassCreate("HI2L_POWER_LV_S" 'spacing)
  unless(nc error("2L netclass create failed\n"))
  axlDBAddProp(list(nc) list(list("SPACING_CONSTRAINT_SET" "HI2L_S_POWER_LV")))
  net=axlDBFindByName('net "V5")
  old=axlNetClassGet(net 'spacing t)
  when(old fprintf(f "CLASS_REASSIGN net=%L domain=%L old=%L new=%L\n" "V5" 'spacing old->name "HI2L_POWER_LV_S") unless(axlNetClassRemove(old net) error("Cannot remove prior class membership\n")))
  unless(axlNetClassAdd(nc net) error("Cannot bind2L netclass member\n"))
  net=axlDBFindByName('net "V3V3")
  old=axlNetClassGet(net 'spacing t)
  when(old fprintf(f "CLASS_REASSIGN net=%L domain=%L old=%L new=%L\n" "V3V3" 'spacing old->name "HI2L_POWER_LV_S") unless(axlNetClassRemove(old net) error("Cannot remove prior class membership\n")))
  unless(axlNetClassAdd(nc net) error("Cannot bind2L netclass member\n"))
  nc=axlNetClassCreate("HI2L_POWER_LV_E" 'electrical)
  unless(nc error("2L netclass create failed\n"))
  net=axlDBFindByName('net "V5")
  old=axlNetClassGet(net 'electrical t)
  when(old fprintf(f "CLASS_REASSIGN net=%L domain=%L old=%L new=%L\n" "V5" 'electrical old->name "HI2L_POWER_LV_E") unless(axlNetClassRemove(old net) error("Cannot remove prior class membership\n")))
  unless(axlNetClassAdd(nc net) error("Cannot bind2L netclass member\n"))
  net=axlDBFindByName('net "V3V3")
  old=axlNetClassGet(net 'electrical t)
  when(old fprintf(f "CLASS_REASSIGN net=%L domain=%L old=%L new=%L\n" "V3V3" 'electrical old->name "HI2L_POWER_LV_E") unless(axlNetClassRemove(old net) error("Cannot remove prior class membership\n")))
  unless(axlNetClassAdd(nc net) error("Cannot bind2L netclass member\n"))
  net=axlDBFindByName('net "V3V3")
  axlDBAddProp(list(net) list(list("PHYSICAL_CONSTRAINT_SET" "HI2L_P_POWER_LV") list("SPACING_CONSTRAINT_SET" "HI2L_S_POWER_LV")))
  unless(axlCNSCreate('physical "HI2L_P_VDDA" nil) error("Cannot create2L physical CSet\n"))
  f29Must(axlCNSSetPhysical("HI2L_P_VDDA" nil 'width_min "0.3 MM") "2L specific physical value")
  f29Must(axlCNSSetPhysical("HI2L_P_VDDA" nil 'neckwidth_min "0.2 MM") "2L specific physical value")
  f29Must(axlCNSSetPhysical("HI2L_P_VDDA" nil 'necklength_max "1.0 MM") "2L specific physical value")
  f29Must(axlCNSSetPhysical("HI2L_P_VDDA" nil 'vias "L28_VIA030_C060") "Approved2L via")
  f29Must(axlCNSSetPhysical("HI2L_P_VDDA" "TOP" 'allow_etch t) "2L layer permission")
  f29Must(axlCNSSetPhysical("HI2L_P_VDDA" "BOTTOM" 'allow_etch t) "2L layer permission")
  unless(axlCNSCreate('spacing "HI2L_S_VDDA" nil) error("Cannot create2L spacing CSet\n"))
  f29Must(axlCNSSetSpacing("HI2L_S_VDDA" nil 'smdpin_line "0.3 MM") "2L explicit spacing value")
  f29Must(axlCNSSetSpacing("HI2L_S_VDDA" nil 'line_line "0.3 MM") "2L explicit spacing value")
  f29Must(axlCNSSetSpacing("HI2L_S_VDDA" nil 'via_line "0.3 MM") "2L explicit spacing value")
  f29Must(axlCNSSetSpacing("HI2L_S_VDDA" nil 'line_shape "0.3 MM") "2L explicit spacing value")
  f29Must(axlCNSSetSpacing("HI2L_S_VDDA" nil 'via_shape "0.3 MM") "2L explicit spacing value")
  f29Must(axlCNSSetSpacing("HI2L_S_VDDA" nil 'shape_shape "0.3 MM") "2L explicit spacing value")
  nc=axlNetClassCreate("HI2L_VDDA_P" 'physical)
  unless(nc error("2L netclass create failed\n"))
  axlDBAddProp(list(nc) list(list("PHYSICAL_CONSTRAINT_SET" "HI2L_P_VDDA")))
  net=axlDBFindByName('net "VDDA")
  old=axlNetClassGet(net 'physical t)
  when(old fprintf(f "CLASS_REASSIGN net=%L domain=%L old=%L new=%L\n" "VDDA" 'physical old->name "HI2L_VDDA_P") unless(axlNetClassRemove(old net) error("Cannot remove prior class membership\n")))
  unless(axlNetClassAdd(nc net) error("Cannot bind2L netclass member\n"))
  nc=axlNetClassCreate("HI2L_VDDA_S" 'spacing)
  unless(nc error("2L netclass create failed\n"))
  axlDBAddProp(list(nc) list(list("SPACING_CONSTRAINT_SET" "HI2L_S_VDDA")))
  net=axlDBFindByName('net "VDDA")
  old=axlNetClassGet(net 'spacing t)
  when(old fprintf(f "CLASS_REASSIGN net=%L domain=%L old=%L new=%L\n" "VDDA" 'spacing old->name "HI2L_VDDA_S") unless(axlNetClassRemove(old net) error("Cannot remove prior class membership\n")))
  unless(axlNetClassAdd(nc net) error("Cannot bind2L netclass member\n"))
  nc=axlNetClassCreate("HI2L_VDDA_E" 'electrical)
  unless(nc error("2L netclass create failed\n"))
  net=axlDBFindByName('net "VDDA")
  old=axlNetClassGet(net 'electrical t)
  when(old fprintf(f "CLASS_REASSIGN net=%L domain=%L old=%L new=%L\n" "VDDA" 'electrical old->name "HI2L_VDDA_E") unless(axlNetClassRemove(old net) error("Cannot remove prior class membership\n")))
  unless(axlNetClassAdd(nc net) error("Cannot bind2L netclass member\n"))
  unless(axlCNSCreate('physical "HI2L_P_GROUND" nil) error("Cannot create2L physical CSet\n"))
  f29Must(axlCNSSetPhysical("HI2L_P_GROUND" nil 'width_min "0.6 MM") "2L specific physical value")
  f29Must(axlCNSSetPhysical("HI2L_P_GROUND" nil 'neckwidth_min "0.25 MM") "2L specific physical value")
  f29Must(axlCNSSetPhysical("HI2L_P_GROUND" nil 'necklength_max "1.0 MM") "2L specific physical value")
  f29Must(axlCNSSetPhysical("HI2L_P_GROUND" nil 'vias "L28_VIA030_C060") "Approved2L via")
  f29Must(axlCNSSetPhysical("HI2L_P_GROUND" "TOP" 'allow_etch t) "2L layer permission")
  f29Must(axlCNSSetPhysical("HI2L_P_GROUND" "BOTTOM" 'allow_etch t) "2L layer permission")
  unless(axlCNSCreate('spacing "HI2L_S_GROUND" nil) error("Cannot create2L spacing CSet\n"))
  f29Must(axlCNSSetSpacing("HI2L_S_GROUND" nil 'smdpin_line "0.3 MM") "2L explicit spacing value")
  f29Must(axlCNSSetSpacing("HI2L_S_GROUND" nil 'line_line "0.3 MM") "2L explicit spacing value")
  f29Must(axlCNSSetSpacing("HI2L_S_GROUND" nil 'via_line "0.3 MM") "2L explicit spacing value")
  f29Must(axlCNSSetSpacing("HI2L_S_GROUND" nil 'line_shape "0.3 MM") "2L explicit spacing value")
  f29Must(axlCNSSetSpacing("HI2L_S_GROUND" nil 'via_shape "0.3 MM") "2L explicit spacing value")
  f29Must(axlCNSSetSpacing("HI2L_S_GROUND" nil 'shape_shape "0.3 MM") "2L explicit spacing value")
  nc=axlNetClassCreate("HI2L_GROUND_P" 'physical)
  unless(nc error("2L netclass create failed\n"))
  axlDBAddProp(list(nc) list(list("PHYSICAL_CONSTRAINT_SET" "HI2L_P_GROUND")))
  net=axlDBFindByName('net "GND")
  old=axlNetClassGet(net 'physical t)
  when(old fprintf(f "CLASS_REASSIGN net=%L domain=%L old=%L new=%L\n" "GND" 'physical old->name "HI2L_GROUND_P") unless(axlNetClassRemove(old net) error("Cannot remove prior class membership\n")))
  unless(axlNetClassAdd(nc net) error("Cannot bind2L netclass member\n"))
  nc=axlNetClassCreate("HI2L_GROUND_S" 'spacing)
  unless(nc error("2L netclass create failed\n"))
  axlDBAddProp(list(nc) list(list("SPACING_CONSTRAINT_SET" "HI2L_S_GROUND")))
  net=axlDBFindByName('net "GND")
  old=axlNetClassGet(net 'spacing t)
  when(old fprintf(f "CLASS_REASSIGN net=%L domain=%L old=%L new=%L\n" "GND" 'spacing old->name "HI2L_GROUND_S") unless(axlNetClassRemove(old net) error("Cannot remove prior class membership\n")))
  unless(axlNetClassAdd(nc net) error("Cannot bind2L netclass member\n"))
  nc=axlNetClassCreate("HI2L_GROUND_E" 'electrical)
  unless(nc error("2L netclass create failed\n"))
  net=axlDBFindByName('net "GND")
  old=axlNetClassGet(net 'electrical t)
  when(old fprintf(f "CLASS_REASSIGN net=%L domain=%L old=%L new=%L\n" "GND" 'electrical old->name "HI2L_GROUND_E") unless(axlNetClassRemove(old net) error("Cannot remove prior class membership\n")))
  unless(axlNetClassAdd(nc net) error("Cannot bind2L netclass member\n"))
  net=axlDBFindByName('net "GND")
  axlDBAddProp(list(net) list(list("PHYSICAL_CONSTRAINT_SET" "HI2L_P_GROUND") list("SPACING_CONSTRAINT_SET" "HI2L_S_GROUND")))
  unless(axlCNSCreate('physical "HI2L_P_SWITCH" nil) error("Cannot create2L physical CSet\n"))
  f29Must(axlCNSSetPhysical("HI2L_P_SWITCH" nil 'width_min "0.6 MM") "2L specific physical value")
  f29Must(axlCNSSetPhysical("HI2L_P_SWITCH" nil 'neckwidth_min "0.25 MM") "2L specific physical value")
  f29Must(axlCNSSetPhysical("HI2L_P_SWITCH" nil 'necklength_max "1.0 MM") "2L specific physical value")
  f29Must(axlCNSSetPhysical("HI2L_P_SWITCH" nil 'vias "L28_VIA030_C060") "Approved2L via")
  f29Must(axlCNSSetPhysical("HI2L_P_SWITCH" "TOP" 'allow_etch t) "2L layer permission")
  f29Must(axlCNSSetPhysical("HI2L_P_SWITCH" "BOTTOM" 'allow_etch nil) "2L layer permission")
  unless(axlCNSCreate('spacing "HI2L_S_SWITCH" nil) error("Cannot create2L spacing CSet\n"))
  f29Must(axlCNSSetSpacing("HI2L_S_SWITCH" nil 'smdpin_line "0.5 MM") "2L explicit spacing value")
  f29Must(axlCNSSetSpacing("HI2L_S_SWITCH" nil 'line_line "0.5 MM") "2L explicit spacing value")
  f29Must(axlCNSSetSpacing("HI2L_S_SWITCH" nil 'via_line "0.5 MM") "2L explicit spacing value")
  f29Must(axlCNSSetSpacing("HI2L_S_SWITCH" nil 'line_shape "0.5 MM") "2L explicit spacing value")
  f29Must(axlCNSSetSpacing("HI2L_S_SWITCH" nil 'via_shape "0.5 MM") "2L explicit spacing value")
  f29Must(axlCNSSetSpacing("HI2L_S_SWITCH" nil 'shape_shape "0.5 MM") "2L explicit spacing value")
  nc=axlNetClassCreate("HI2L_SWITCH_P" 'physical)
  unless(nc error("2L netclass create failed\n"))
  axlDBAddProp(list(nc) list(list("PHYSICAL_CONSTRAINT_SET" "HI2L_P_SWITCH")))
  net=axlDBFindByName('net "BUCK_SW")
  old=axlNetClassGet(net 'physical t)
  when(old fprintf(f "CLASS_REASSIGN net=%L domain=%L old=%L new=%L\n" "BUCK_SW" 'physical old->name "HI2L_SWITCH_P") unless(axlNetClassRemove(old net) error("Cannot remove prior class membership\n")))
  unless(axlNetClassAdd(nc net) error("Cannot bind2L netclass member\n"))
  net=axlDBFindByName('net "BUCK_BOOT")
  old=axlNetClassGet(net 'physical t)
  when(old fprintf(f "CLASS_REASSIGN net=%L domain=%L old=%L new=%L\n" "BUCK_BOOT" 'physical old->name "HI2L_SWITCH_P") unless(axlNetClassRemove(old net) error("Cannot remove prior class membership\n")))
  unless(axlNetClassAdd(nc net) error("Cannot bind2L netclass member\n"))
  nc=axlNetClassCreate("HI2L_SWITCH_S" 'spacing)
  unless(nc error("2L netclass create failed\n"))
  axlDBAddProp(list(nc) list(list("SPACING_CONSTRAINT_SET" "HI2L_S_SWITCH")))
  net=axlDBFindByName('net "BUCK_SW")
  old=axlNetClassGet(net 'spacing t)
  when(old fprintf(f "CLASS_REASSIGN net=%L domain=%L old=%L new=%L\n" "BUCK_SW" 'spacing old->name "HI2L_SWITCH_S") unless(axlNetClassRemove(old net) error("Cannot remove prior class membership\n")))
  unless(axlNetClassAdd(nc net) error("Cannot bind2L netclass member\n"))
  net=axlDBFindByName('net "BUCK_BOOT")
  old=axlNetClassGet(net 'spacing t)
  when(old fprintf(f "CLASS_REASSIGN net=%L domain=%L old=%L new=%L\n" "BUCK_BOOT" 'spacing old->name "HI2L_SWITCH_S") unless(axlNetClassRemove(old net) error("Cannot remove prior class membership\n")))
  unless(axlNetClassAdd(nc net) error("Cannot bind2L netclass member\n"))
  nc=axlNetClassCreate("HI2L_SWITCH_E" 'electrical)
  unless(nc error("2L netclass create failed\n"))
  net=axlDBFindByName('net "BUCK_SW")
  old=axlNetClassGet(net 'electrical t)
  when(old fprintf(f "CLASS_REASSIGN net=%L domain=%L old=%L new=%L\n" "BUCK_SW" 'electrical old->name "HI2L_SWITCH_E") unless(axlNetClassRemove(old net) error("Cannot remove prior class membership\n")))
  unless(axlNetClassAdd(nc net) error("Cannot bind2L netclass member\n"))
  net=axlDBFindByName('net "BUCK_BOOT")
  old=axlNetClassGet(net 'electrical t)
  when(old fprintf(f "CLASS_REASSIGN net=%L domain=%L old=%L new=%L\n" "BUCK_BOOT" 'electrical old->name "HI2L_SWITCH_E") unless(axlNetClassRemove(old net) error("Cannot remove prior class membership\n")))
  unless(axlNetClassAdd(nc net) error("Cannot bind2L netclass member\n"))
  unless(axlCNSCreate('physical "HI2L_P_FEEDBACK" nil) error("Cannot create2L physical CSet\n"))
  f29Must(axlCNSSetPhysical("HI2L_P_FEEDBACK" nil 'width_min "0.2 MM") "2L specific physical value")
  f29Must(axlCNSSetPhysical("HI2L_P_FEEDBACK" nil 'neckwidth_min "0.16 MM") "2L specific physical value")
  f29Must(axlCNSSetPhysical("HI2L_P_FEEDBACK" nil 'necklength_max "1.0 MM") "2L specific physical value")
  f29Must(axlCNSSetPhysical("HI2L_P_FEEDBACK" nil 'vias "L28_VIA030_C060") "Approved2L via")
  f29Must(axlCNSSetPhysical("HI2L_P_FEEDBACK" "TOP" 'allow_etch t) "2L layer permission")
  f29Must(axlCNSSetPhysical("HI2L_P_FEEDBACK" "BOTTOM" 'allow_etch nil) "2L layer permission")
  unless(axlCNSCreate('spacing "HI2L_S_FEEDBACK" nil) error("Cannot create2L spacing CSet\n"))
  f29Must(axlCNSSetSpacing("HI2L_S_FEEDBACK" nil 'smdpin_line "0.3 MM") "2L explicit spacing value")
  f29Must(axlCNSSetSpacing("HI2L_S_FEEDBACK" nil 'line_line "0.3 MM") "2L explicit spacing value")
  f29Must(axlCNSSetSpacing("HI2L_S_FEEDBACK" nil 'via_line "0.3 MM") "2L explicit spacing value")
  f29Must(axlCNSSetSpacing("HI2L_S_FEEDBACK" nil 'line_shape "0.3 MM") "2L explicit spacing value")
  f29Must(axlCNSSetSpacing("HI2L_S_FEEDBACK" nil 'via_shape "0.3 MM") "2L explicit spacing value")
  f29Must(axlCNSSetSpacing("HI2L_S_FEEDBACK" nil 'shape_shape "0.3 MM") "2L explicit spacing value")
  nc=axlNetClassCreate("HI2L_FEEDBACK_P" 'physical)
  unless(nc error("2L netclass create failed\n"))
  axlDBAddProp(list(nc) list(list("PHYSICAL_CONSTRAINT_SET" "HI2L_P_FEEDBACK")))
  net=axlDBFindByName('net "BUCK_FB")
  old=axlNetClassGet(net 'physical t)
  when(old fprintf(f "CLASS_REASSIGN net=%L domain=%L old=%L new=%L\n" "BUCK_FB" 'physical old->name "HI2L_FEEDBACK_P") unless(axlNetClassRemove(old net) error("Cannot remove prior class membership\n")))
  unless(axlNetClassAdd(nc net) error("Cannot bind2L netclass member\n"))
  nc=axlNetClassCreate("HI2L_FEEDBACK_S" 'spacing)
  unless(nc error("2L netclass create failed\n"))
  axlDBAddProp(list(nc) list(list("SPACING_CONSTRAINT_SET" "HI2L_S_FEEDBACK")))
  net=axlDBFindByName('net "BUCK_FB")
  old=axlNetClassGet(net 'spacing t)
  when(old fprintf(f "CLASS_REASSIGN net=%L domain=%L old=%L new=%L\n" "BUCK_FB" 'spacing old->name "HI2L_FEEDBACK_S") unless(axlNetClassRemove(old net) error("Cannot remove prior class membership\n")))
  unless(axlNetClassAdd(nc net) error("Cannot bind2L netclass member\n"))
  nc=axlNetClassCreate("HI2L_FEEDBACK_E" 'electrical)
  unless(nc error("2L netclass create failed\n"))
  net=axlDBFindByName('net "BUCK_FB")
  old=axlNetClassGet(net 'electrical t)
  when(old fprintf(f "CLASS_REASSIGN net=%L domain=%L old=%L new=%L\n" "BUCK_FB" 'electrical old->name "HI2L_FEEDBACK_E") unless(axlNetClassRemove(old net) error("Cannot remove prior class membership\n")))
  unless(axlNetClassAdd(nc net) error("Cannot bind2L netclass member\n"))
  unless(axlCNSCreate('physical "HI2L_P_USB_FS" nil) error("Cannot create2L physical CSet\n"))
  f29Must(axlCNSSetPhysical("HI2L_P_USB_FS" nil 'width_min "0.2 MM") "2L specific physical value")
  f29Must(axlCNSSetPhysical("HI2L_P_USB_FS" nil 'neckwidth_min "0.16 MM") "2L specific physical value")
  f29Must(axlCNSSetPhysical("HI2L_P_USB_FS" nil 'necklength_max "1.0 MM") "2L specific physical value")
  f29Must(axlCNSSetPhysical("HI2L_P_USB_FS" nil 'vias "L28_VIA030_C060") "Approved2L via")
  f29Must(axlCNSSetPhysical("HI2L_P_USB_FS" "TOP" 'allow_etch t) "2L layer permission")
  f29Must(axlCNSSetPhysical("HI2L_P_USB_FS" "BOTTOM" 'allow_etch t) "2L layer permission")
  unless(axlCNSCreate('spacing "HI2L_S_USB_FS" nil) error("Cannot create2L spacing CSet\n"))
  f29Must(axlCNSSetSpacing("HI2L_S_USB_FS" nil 'smdpin_line "0.16 MM") "2L explicit spacing value")
  f29Must(axlCNSSetSpacing("HI2L_S_USB_FS" nil 'line_line "0.16 MM") "2L explicit spacing value")
  f29Must(axlCNSSetSpacing("HI2L_S_USB_FS" nil 'via_line "0.16 MM") "2L explicit spacing value")
  f29Must(axlCNSSetSpacing("HI2L_S_USB_FS" nil 'line_shape "0.16 MM") "2L explicit spacing value")
  f29Must(axlCNSSetSpacing("HI2L_S_USB_FS" nil 'via_shape "0.16 MM") "2L explicit spacing value")
  f29Must(axlCNSSetSpacing("HI2L_S_USB_FS" nil 'shape_shape "0.16 MM") "2L explicit spacing value")
  nc=axlNetClassCreate("HI2L_USB_FS_P" 'physical)
  unless(nc error("2L netclass create failed\n"))
  axlDBAddProp(list(nc) list(list("PHYSICAL_CONSTRAINT_SET" "HI2L_P_USB_FS")))
  net=axlDBFindByName('net "USB_DP")
  old=axlNetClassGet(net 'physical t)
  when(old fprintf(f "CLASS_REASSIGN net=%L domain=%L old=%L new=%L\n" "USB_DP" 'physical old->name "HI2L_USB_FS_P") unless(axlNetClassRemove(old net) error("Cannot remove prior class membership\n")))
  unless(axlNetClassAdd(nc net) error("Cannot bind2L netclass member\n"))
  net=axlDBFindByName('net "USB_DM")
  old=axlNetClassGet(net 'physical t)
  when(old fprintf(f "CLASS_REASSIGN net=%L domain=%L old=%L new=%L\n" "USB_DM" 'physical old->name "HI2L_USB_FS_P") unless(axlNetClassRemove(old net) error("Cannot remove prior class membership\n")))
  unless(axlNetClassAdd(nc net) error("Cannot bind2L netclass member\n"))
  net=axlDBFindByName('net "PA11_SHARED")
  old=axlNetClassGet(net 'physical t)
  when(old fprintf(f "CLASS_REASSIGN net=%L domain=%L old=%L new=%L\n" "PA11_SHARED" 'physical old->name "HI2L_USB_FS_P") unless(axlNetClassRemove(old net) error("Cannot remove prior class membership\n")))
  unless(axlNetClassAdd(nc net) error("Cannot bind2L netclass member\n"))
  net=axlDBFindByName('net "PA12_SHARED")
  old=axlNetClassGet(net 'physical t)
  when(old fprintf(f "CLASS_REASSIGN net=%L domain=%L old=%L new=%L\n" "PA12_SHARED" 'physical old->name "HI2L_USB_FS_P") unless(axlNetClassRemove(old net) error("Cannot remove prior class membership\n")))
  unless(axlNetClassAdd(nc net) error("Cannot bind2L netclass member\n"))
  nc=axlNetClassCreate("HI2L_USB_FS_S" 'spacing)
  unless(nc error("2L netclass create failed\n"))
  axlDBAddProp(list(nc) list(list("SPACING_CONSTRAINT_SET" "HI2L_S_USB_FS")))
  net=axlDBFindByName('net "USB_DP")
  old=axlNetClassGet(net 'spacing t)
  when(old fprintf(f "CLASS_REASSIGN net=%L domain=%L old=%L new=%L\n" "USB_DP" 'spacing old->name "HI2L_USB_FS_S") unless(axlNetClassRemove(old net) error("Cannot remove prior class membership\n")))
  unless(axlNetClassAdd(nc net) error("Cannot bind2L netclass member\n"))
  net=axlDBFindByName('net "USB_DM")
  old=axlNetClassGet(net 'spacing t)
  when(old fprintf(f "CLASS_REASSIGN net=%L domain=%L old=%L new=%L\n" "USB_DM" 'spacing old->name "HI2L_USB_FS_S") unless(axlNetClassRemove(old net) error("Cannot remove prior class membership\n")))
  unless(axlNetClassAdd(nc net) error("Cannot bind2L netclass member\n"))
  net=axlDBFindByName('net "PA11_SHARED")
  old=axlNetClassGet(net 'spacing t)
  when(old fprintf(f "CLASS_REASSIGN net=%L domain=%L old=%L new=%L\n" "PA11_SHARED" 'spacing old->name "HI2L_USB_FS_S") unless(axlNetClassRemove(old net) error("Cannot remove prior class membership\n")))
  unless(axlNetClassAdd(nc net) error("Cannot bind2L netclass member\n"))
  net=axlDBFindByName('net "PA12_SHARED")
  old=axlNetClassGet(net 'spacing t)
  when(old fprintf(f "CLASS_REASSIGN net=%L domain=%L old=%L new=%L\n" "PA12_SHARED" 'spacing old->name "HI2L_USB_FS_S") unless(axlNetClassRemove(old net) error("Cannot remove prior class membership\n")))
  unless(axlNetClassAdd(nc net) error("Cannot bind2L netclass member\n"))
  nc=axlNetClassCreate("HI2L_USB_FS_E" 'electrical)
  unless(nc error("2L netclass create failed\n"))
  net=axlDBFindByName('net "USB_DP")
  old=axlNetClassGet(net 'electrical t)
  when(old fprintf(f "CLASS_REASSIGN net=%L domain=%L old=%L new=%L\n" "USB_DP" 'electrical old->name "HI2L_USB_FS_E") unless(axlNetClassRemove(old net) error("Cannot remove prior class membership\n")))
  unless(axlNetClassAdd(nc net) error("Cannot bind2L netclass member\n"))
  net=axlDBFindByName('net "USB_DM")
  old=axlNetClassGet(net 'electrical t)
  when(old fprintf(f "CLASS_REASSIGN net=%L domain=%L old=%L new=%L\n" "USB_DM" 'electrical old->name "HI2L_USB_FS_E") unless(axlNetClassRemove(old net) error("Cannot remove prior class membership\n")))
  unless(axlNetClassAdd(nc net) error("Cannot bind2L netclass member\n"))
  net=axlDBFindByName('net "PA11_SHARED")
  old=axlNetClassGet(net 'electrical t)
  when(old fprintf(f "CLASS_REASSIGN net=%L domain=%L old=%L new=%L\n" "PA11_SHARED" 'electrical old->name "HI2L_USB_FS_E") unless(axlNetClassRemove(old net) error("Cannot remove prior class membership\n")))
  unless(axlNetClassAdd(nc net) error("Cannot bind2L netclass member\n"))
  net=axlDBFindByName('net "PA12_SHARED")
  old=axlNetClassGet(net 'electrical t)
  when(old fprintf(f "CLASS_REASSIGN net=%L domain=%L old=%L new=%L\n" "PA12_SHARED" 'electrical old->name "HI2L_USB_FS_E") unless(axlNetClassRemove(old net) error("Cannot remove prior class membership\n")))
  unless(axlNetClassAdd(nc net) error("Cannot bind2L netclass member\n"))
  unless(axlCNSCreate('physical "HI2L_P_OSCILLATOR" nil) error("Cannot create2L physical CSet\n"))
  f29Must(axlCNSSetPhysical("HI2L_P_OSCILLATOR" nil 'width_min "0.2 MM") "2L specific physical value")
  f29Must(axlCNSSetPhysical("HI2L_P_OSCILLATOR" nil 'neckwidth_min "0.16 MM") "2L specific physical value")
  f29Must(axlCNSSetPhysical("HI2L_P_OSCILLATOR" nil 'necklength_max "1.0 MM") "2L specific physical value")
  f29Must(axlCNSSetPhysical("HI2L_P_OSCILLATOR" nil 'vias "L28_VIA030_C060") "Approved2L via")
  f29Must(axlCNSSetPhysical("HI2L_P_OSCILLATOR" "TOP" 'allow_etch t) "2L layer permission")
  f29Must(axlCNSSetPhysical("HI2L_P_OSCILLATOR" "BOTTOM" 'allow_etch nil) "2L layer permission")
  unless(axlCNSCreate('spacing "HI2L_S_OSCILLATOR" nil) error("Cannot create2L spacing CSet\n"))
  f29Must(axlCNSSetSpacing("HI2L_S_OSCILLATOR" nil 'smdpin_line "0.3 MM") "2L explicit spacing value")
  f29Must(axlCNSSetSpacing("HI2L_S_OSCILLATOR" nil 'line_line "0.3 MM") "2L explicit spacing value")
  f29Must(axlCNSSetSpacing("HI2L_S_OSCILLATOR" nil 'via_line "0.3 MM") "2L explicit spacing value")
  f29Must(axlCNSSetSpacing("HI2L_S_OSCILLATOR" nil 'line_shape "0.3 MM") "2L explicit spacing value")
  f29Must(axlCNSSetSpacing("HI2L_S_OSCILLATOR" nil 'via_shape "0.3 MM") "2L explicit spacing value")
  f29Must(axlCNSSetSpacing("HI2L_S_OSCILLATOR" nil 'shape_shape "0.3 MM") "2L explicit spacing value")
  nc=axlNetClassCreate("HI2L_OSCILLATOR_P" 'physical)
  unless(nc error("2L netclass create failed\n"))
  axlDBAddProp(list(nc) list(list("PHYSICAL_CONSTRAINT_SET" "HI2L_P_OSCILLATOR")))
  net=axlDBFindByName('net "OSC_IN")
  old=axlNetClassGet(net 'physical t)
  when(old fprintf(f "CLASS_REASSIGN net=%L domain=%L old=%L new=%L\n" "OSC_IN" 'physical old->name "HI2L_OSCILLATOR_P") unless(axlNetClassRemove(old net) error("Cannot remove prior class membership\n")))
  unless(axlNetClassAdd(nc net) error("Cannot bind2L netclass member\n"))
  net=axlDBFindByName('net "OSC_OUT")
  old=axlNetClassGet(net 'physical t)
  when(old fprintf(f "CLASS_REASSIGN net=%L domain=%L old=%L new=%L\n" "OSC_OUT" 'physical old->name "HI2L_OSCILLATOR_P") unless(axlNetClassRemove(old net) error("Cannot remove prior class membership\n")))
  unless(axlNetClassAdd(nc net) error("Cannot bind2L netclass member\n"))
  net=axlDBFindByName('net "XTAL_OUT")
  old=axlNetClassGet(net 'physical t)
  when(old fprintf(f "CLASS_REASSIGN net=%L domain=%L old=%L new=%L\n" "XTAL_OUT" 'physical old->name "HI2L_OSCILLATOR_P") unless(axlNetClassRemove(old net) error("Cannot remove prior class membership\n")))
  unless(axlNetClassAdd(nc net) error("Cannot bind2L netclass member\n"))
  nc=axlNetClassCreate("HI2L_OSCILLATOR_S" 'spacing)
  unless(nc error("2L netclass create failed\n"))
  axlDBAddProp(list(nc) list(list("SPACING_CONSTRAINT_SET" "HI2L_S_OSCILLATOR")))
  net=axlDBFindByName('net "OSC_IN")
  old=axlNetClassGet(net 'spacing t)
  when(old fprintf(f "CLASS_REASSIGN net=%L domain=%L old=%L new=%L\n" "OSC_IN" 'spacing old->name "HI2L_OSCILLATOR_S") unless(axlNetClassRemove(old net) error("Cannot remove prior class membership\n")))
  unless(axlNetClassAdd(nc net) error("Cannot bind2L netclass member\n"))
  net=axlDBFindByName('net "OSC_OUT")
  old=axlNetClassGet(net 'spacing t)
  when(old fprintf(f "CLASS_REASSIGN net=%L domain=%L old=%L new=%L\n" "OSC_OUT" 'spacing old->name "HI2L_OSCILLATOR_S") unless(axlNetClassRemove(old net) error("Cannot remove prior class membership\n")))
  unless(axlNetClassAdd(nc net) error("Cannot bind2L netclass member\n"))
  net=axlDBFindByName('net "XTAL_OUT")
  old=axlNetClassGet(net 'spacing t)
  when(old fprintf(f "CLASS_REASSIGN net=%L domain=%L old=%L new=%L\n" "XTAL_OUT" 'spacing old->name "HI2L_OSCILLATOR_S") unless(axlNetClassRemove(old net) error("Cannot remove prior class membership\n")))
  unless(axlNetClassAdd(nc net) error("Cannot bind2L netclass member\n"))
  nc=axlNetClassCreate("HI2L_OSCILLATOR_E" 'electrical)
  unless(nc error("2L netclass create failed\n"))
  net=axlDBFindByName('net "OSC_IN")
  old=axlNetClassGet(net 'electrical t)
  when(old fprintf(f "CLASS_REASSIGN net=%L domain=%L old=%L new=%L\n" "OSC_IN" 'electrical old->name "HI2L_OSCILLATOR_E") unless(axlNetClassRemove(old net) error("Cannot remove prior class membership\n")))
  unless(axlNetClassAdd(nc net) error("Cannot bind2L netclass member\n"))
  net=axlDBFindByName('net "OSC_OUT")
  old=axlNetClassGet(net 'electrical t)
  when(old fprintf(f "CLASS_REASSIGN net=%L domain=%L old=%L new=%L\n" "OSC_OUT" 'electrical old->name "HI2L_OSCILLATOR_E") unless(axlNetClassRemove(old net) error("Cannot remove prior class membership\n")))
  unless(axlNetClassAdd(nc net) error("Cannot bind2L netclass member\n"))
  net=axlDBFindByName('net "XTAL_OUT")
  old=axlNetClassGet(net 'electrical t)
  when(old fprintf(f "CLASS_REASSIGN net=%L domain=%L old=%L new=%L\n" "XTAL_OUT" 'electrical old->name "HI2L_OSCILLATOR_E") unless(axlNetClassRemove(old net) error("Cannot remove prior class membership\n")))
  unless(axlNetClassAdd(nc net) error("Cannot bind2L netclass member\n"))
  unless(axlCNSCreate('physical "HI2L_P_ADC" nil) error("Cannot create2L physical CSet\n"))
  f29Must(axlCNSSetPhysical("HI2L_P_ADC" nil 'width_min "0.2 MM") "2L specific physical value")
  f29Must(axlCNSSetPhysical("HI2L_P_ADC" nil 'neckwidth_min "0.16 MM") "2L specific physical value")
  f29Must(axlCNSSetPhysical("HI2L_P_ADC" nil 'necklength_max "1.0 MM") "2L specific physical value")
  f29Must(axlCNSSetPhysical("HI2L_P_ADC" nil 'vias "L28_VIA030_C060") "Approved2L via")
  f29Must(axlCNSSetPhysical("HI2L_P_ADC" "TOP" 'allow_etch t) "2L layer permission")
  f29Must(axlCNSSetPhysical("HI2L_P_ADC" "BOTTOM" 'allow_etch nil) "2L layer permission")
  unless(axlCNSCreate('spacing "HI2L_S_ADC" nil) error("Cannot create2L spacing CSet\n"))
  f29Must(axlCNSSetSpacing("HI2L_S_ADC" nil 'smdpin_line "0.3 MM") "2L explicit spacing value")
  f29Must(axlCNSSetSpacing("HI2L_S_ADC" nil 'line_line "0.3 MM") "2L explicit spacing value")
  f29Must(axlCNSSetSpacing("HI2L_S_ADC" nil 'via_line "0.3 MM") "2L explicit spacing value")
  f29Must(axlCNSSetSpacing("HI2L_S_ADC" nil 'line_shape "0.3 MM") "2L explicit spacing value")
  f29Must(axlCNSSetSpacing("HI2L_S_ADC" nil 'via_shape "0.3 MM") "2L explicit spacing value")
  f29Must(axlCNSSetSpacing("HI2L_S_ADC" nil 'shape_shape "0.3 MM") "2L explicit spacing value")
  nc=axlNetClassCreate("HI2L_ADC_P" 'physical)
  unless(nc error("2L netclass create failed\n"))
  axlDBAddProp(list(nc) list(list("PHYSICAL_CONSTRAINT_SET" "HI2L_P_ADC")))
  net=axlDBFindByName('net "ADC_IN")
  old=axlNetClassGet(net 'physical t)
  when(old fprintf(f "CLASS_REASSIGN net=%L domain=%L old=%L new=%L\n" "ADC_IN" 'physical old->name "HI2L_ADC_P") unless(axlNetClassRemove(old net) error("Cannot remove prior class membership\n")))
  unless(axlNetClassAdd(nc net) error("Cannot bind2L netclass member\n"))
  net=axlDBFindByName('net "ADC0")
  old=axlNetClassGet(net 'physical t)
  when(old fprintf(f "CLASS_REASSIGN net=%L domain=%L old=%L new=%L\n" "ADC0" 'physical old->name "HI2L_ADC_P") unless(axlNetClassRemove(old net) error("Cannot remove prior class membership\n")))
  unless(axlNetClassAdd(nc net) error("Cannot bind2L netclass member\n"))
  nc=axlNetClassCreate("HI2L_ADC_S" 'spacing)
  unless(nc error("2L netclass create failed\n"))
  axlDBAddProp(list(nc) list(list("SPACING_CONSTRAINT_SET" "HI2L_S_ADC")))
  net=axlDBFindByName('net "ADC_IN")
  old=axlNetClassGet(net 'spacing t)
  when(old fprintf(f "CLASS_REASSIGN net=%L domain=%L old=%L new=%L\n" "ADC_IN" 'spacing old->name "HI2L_ADC_S") unless(axlNetClassRemove(old net) error("Cannot remove prior class membership\n")))
  unless(axlNetClassAdd(nc net) error("Cannot bind2L netclass member\n"))
  net=axlDBFindByName('net "ADC0")
  old=axlNetClassGet(net 'spacing t)
  when(old fprintf(f "CLASS_REASSIGN net=%L domain=%L old=%L new=%L\n" "ADC0" 'spacing old->name "HI2L_ADC_S") unless(axlNetClassRemove(old net) error("Cannot remove prior class membership\n")))
  unless(axlNetClassAdd(nc net) error("Cannot bind2L netclass member\n"))
  nc=axlNetClassCreate("HI2L_ADC_E" 'electrical)
  unless(nc error("2L netclass create failed\n"))
  net=axlDBFindByName('net "ADC_IN")
  old=axlNetClassGet(net 'electrical t)
  when(old fprintf(f "CLASS_REASSIGN net=%L domain=%L old=%L new=%L\n" "ADC_IN" 'electrical old->name "HI2L_ADC_E") unless(axlNetClassRemove(old net) error("Cannot remove prior class membership\n")))
  unless(axlNetClassAdd(nc net) error("Cannot bind2L netclass member\n"))
  net=axlDBFindByName('net "ADC0")
  old=axlNetClassGet(net 'electrical t)
  when(old fprintf(f "CLASS_REASSIGN net=%L domain=%L old=%L new=%L\n" "ADC0" 'electrical old->name "HI2L_ADC_E") unless(axlNetClassRemove(old net) error("Cannot remove prior class membership\n")))
  unless(axlNetClassAdd(nc net) error("Cannot bind2L netclass member\n"))
  unless(axlCNSCreate('physical "HI2L_P_CAN_BUS" nil) error("Cannot create2L physical CSet\n"))
  f29Must(axlCNSSetPhysical("HI2L_P_CAN_BUS" nil 'width_min "0.3 MM") "2L specific physical value")
  f29Must(axlCNSSetPhysical("HI2L_P_CAN_BUS" nil 'neckwidth_min "0.2 MM") "2L specific physical value")
  f29Must(axlCNSSetPhysical("HI2L_P_CAN_BUS" nil 'necklength_max "1.0 MM") "2L specific physical value")
  f29Must(axlCNSSetPhysical("HI2L_P_CAN_BUS" nil 'vias "L28_VIA030_C060") "Approved2L via")
  f29Must(axlCNSSetPhysical("HI2L_P_CAN_BUS" "TOP" 'allow_etch t) "2L layer permission")
  f29Must(axlCNSSetPhysical("HI2L_P_CAN_BUS" "BOTTOM" 'allow_etch t) "2L layer permission")
  unless(axlCNSCreate('spacing "HI2L_S_CAN_BUS" nil) error("Cannot create2L spacing CSet\n"))
  f29Must(axlCNSSetSpacing("HI2L_S_CAN_BUS" nil 'smdpin_line "0.2 MM") "2L explicit spacing value")
  f29Must(axlCNSSetSpacing("HI2L_S_CAN_BUS" nil 'line_line "0.2 MM") "2L explicit spacing value")
  f29Must(axlCNSSetSpacing("HI2L_S_CAN_BUS" nil 'via_line "0.2 MM") "2L explicit spacing value")
  f29Must(axlCNSSetSpacing("HI2L_S_CAN_BUS" nil 'line_shape "0.2 MM") "2L explicit spacing value")
  f29Must(axlCNSSetSpacing("HI2L_S_CAN_BUS" nil 'via_shape "0.2 MM") "2L explicit spacing value")
  f29Must(axlCNSSetSpacing("HI2L_S_CAN_BUS" nil 'shape_shape "0.2 MM") "2L explicit spacing value")
  nc=axlNetClassCreate("HI2L_CAN_BUS_P" 'physical)
  unless(nc error("2L netclass create failed\n"))
  axlDBAddProp(list(nc) list(list("PHYSICAL_CONSTRAINT_SET" "HI2L_P_CAN_BUS")))
  net=axlDBFindByName('net "CAN_H")
  old=axlNetClassGet(net 'physical t)
  when(old fprintf(f "CLASS_REASSIGN net=%L domain=%L old=%L new=%L\n" "CAN_H" 'physical old->name "HI2L_CAN_BUS_P") unless(axlNetClassRemove(old net) error("Cannot remove prior class membership\n")))
  unless(axlNetClassAdd(nc net) error("Cannot bind2L netclass member\n"))
  net=axlDBFindByName('net "CAN_L")
  old=axlNetClassGet(net 'physical t)
  when(old fprintf(f "CLASS_REASSIGN net=%L domain=%L old=%L new=%L\n" "CAN_L" 'physical old->name "HI2L_CAN_BUS_P") unless(axlNetClassRemove(old net) error("Cannot remove prior class membership\n")))
  unless(axlNetClassAdd(nc net) error("Cannot bind2L netclass member\n"))
  nc=axlNetClassCreate("HI2L_CAN_BUS_S" 'spacing)
  unless(nc error("2L netclass create failed\n"))
  axlDBAddProp(list(nc) list(list("SPACING_CONSTRAINT_SET" "HI2L_S_CAN_BUS")))
  net=axlDBFindByName('net "CAN_H")
  old=axlNetClassGet(net 'spacing t)
  when(old fprintf(f "CLASS_REASSIGN net=%L domain=%L old=%L new=%L\n" "CAN_H" 'spacing old->name "HI2L_CAN_BUS_S") unless(axlNetClassRemove(old net) error("Cannot remove prior class membership\n")))
  unless(axlNetClassAdd(nc net) error("Cannot bind2L netclass member\n"))
  net=axlDBFindByName('net "CAN_L")
  old=axlNetClassGet(net 'spacing t)
  when(old fprintf(f "CLASS_REASSIGN net=%L domain=%L old=%L new=%L\n" "CAN_L" 'spacing old->name "HI2L_CAN_BUS_S") unless(axlNetClassRemove(old net) error("Cannot remove prior class membership\n")))
  unless(axlNetClassAdd(nc net) error("Cannot bind2L netclass member\n"))
  nc=axlNetClassCreate("HI2L_CAN_BUS_E" 'electrical)
  unless(nc error("2L netclass create failed\n"))
  net=axlDBFindByName('net "CAN_H")
  old=axlNetClassGet(net 'electrical t)
  when(old fprintf(f "CLASS_REASSIGN net=%L domain=%L old=%L new=%L\n" "CAN_H" 'electrical old->name "HI2L_CAN_BUS_E") unless(axlNetClassRemove(old net) error("Cannot remove prior class membership\n")))
  unless(axlNetClassAdd(nc net) error("Cannot bind2L netclass member\n"))
  net=axlDBFindByName('net "CAN_L")
  old=axlNetClassGet(net 'electrical t)
  when(old fprintf(f "CLASS_REASSIGN net=%L domain=%L old=%L new=%L\n" "CAN_L" 'electrical old->name "HI2L_CAN_BUS_E") unless(axlNetClassRemove(old net) error("Cannot remove prior class membership\n")))
  unless(axlNetClassAdd(nc net) error("Cannot bind2L netclass member\n"))
  unless(axlCNSCreate('physical "HI2L_P_USB_VBUS" nil) error("Cannot create2L physical CSet\n"))
  f29Must(axlCNSSetPhysical("HI2L_P_USB_VBUS" nil 'width_min "0.4 MM") "2L specific physical value")
  f29Must(axlCNSSetPhysical("HI2L_P_USB_VBUS" nil 'neckwidth_min "0.2 MM") "2L specific physical value")
  f29Must(axlCNSSetPhysical("HI2L_P_USB_VBUS" nil 'necklength_max "1.0 MM") "2L specific physical value")
  f29Must(axlCNSSetPhysical("HI2L_P_USB_VBUS" nil 'vias "L28_VIA030_C060") "Approved2L via")
  f29Must(axlCNSSetPhysical("HI2L_P_USB_VBUS" "TOP" 'allow_etch t) "2L layer permission")
  f29Must(axlCNSSetPhysical("HI2L_P_USB_VBUS" "BOTTOM" 'allow_etch t) "2L layer permission")
  unless(axlCNSCreate('spacing "HI2L_S_USB_VBUS" nil) error("Cannot create2L spacing CSet\n"))
  f29Must(axlCNSSetSpacing("HI2L_S_USB_VBUS" nil 'smdpin_line "0.2 MM") "2L explicit spacing value")
  f29Must(axlCNSSetSpacing("HI2L_S_USB_VBUS" nil 'line_line "0.2 MM") "2L explicit spacing value")
  f29Must(axlCNSSetSpacing("HI2L_S_USB_VBUS" nil 'via_line "0.2 MM") "2L explicit spacing value")
  f29Must(axlCNSSetSpacing("HI2L_S_USB_VBUS" nil 'line_shape "0.2 MM") "2L explicit spacing value")
  f29Must(axlCNSSetSpacing("HI2L_S_USB_VBUS" nil 'via_shape "0.2 MM") "2L explicit spacing value")
  f29Must(axlCNSSetSpacing("HI2L_S_USB_VBUS" nil 'shape_shape "0.2 MM") "2L explicit spacing value")
  nc=axlNetClassCreate("HI2L_USB_VBUS_P" 'physical)
  unless(nc error("2L netclass create failed\n"))
  axlDBAddProp(list(nc) list(list("PHYSICAL_CONSTRAINT_SET" "HI2L_P_USB_VBUS")))
  net=axlDBFindByName('net "USB_VBUS")
  old=axlNetClassGet(net 'physical t)
  when(old fprintf(f "CLASS_REASSIGN net=%L domain=%L old=%L new=%L\n" "USB_VBUS" 'physical old->name "HI2L_USB_VBUS_P") unless(axlNetClassRemove(old net) error("Cannot remove prior class membership\n")))
  unless(axlNetClassAdd(nc net) error("Cannot bind2L netclass member\n"))
  nc=axlNetClassCreate("HI2L_USB_VBUS_S" 'spacing)
  unless(nc error("2L netclass create failed\n"))
  axlDBAddProp(list(nc) list(list("SPACING_CONSTRAINT_SET" "HI2L_S_USB_VBUS")))
  net=axlDBFindByName('net "USB_VBUS")
  old=axlNetClassGet(net 'spacing t)
  when(old fprintf(f "CLASS_REASSIGN net=%L domain=%L old=%L new=%L\n" "USB_VBUS" 'spacing old->name "HI2L_USB_VBUS_S") unless(axlNetClassRemove(old net) error("Cannot remove prior class membership\n")))
  unless(axlNetClassAdd(nc net) error("Cannot bind2L netclass member\n"))
  nc=axlNetClassCreate("HI2L_USB_VBUS_E" 'electrical)
  unless(nc error("2L netclass create failed\n"))
  net=axlDBFindByName('net "USB_VBUS")
  old=axlNetClassGet(net 'electrical t)
  when(old fprintf(f "CLASS_REASSIGN net=%L domain=%L old=%L new=%L\n" "USB_VBUS" 'electrical old->name "HI2L_USB_VBUS_E") unless(axlNetClassRemove(old net) error("Cannot remove prior class membership\n")))
  unless(axlNetClassAdd(nc net) error("Cannot bind2L netclass member\n"))
  unless(axlCNSCreate('physical "HI2L_P_USB_AUX" nil) error("Cannot create2L physical CSet\n"))
  f29Must(axlCNSSetPhysical("HI2L_P_USB_AUX" nil 'width_min "0.2 MM") "2L specific physical value")
  f29Must(axlCNSSetPhysical("HI2L_P_USB_AUX" nil 'neckwidth_min "0.16 MM") "2L specific physical value")
  f29Must(axlCNSSetPhysical("HI2L_P_USB_AUX" nil 'necklength_max "1.0 MM") "2L specific physical value")
  f29Must(axlCNSSetPhysical("HI2L_P_USB_AUX" nil 'vias "L28_VIA030_C060") "Approved2L via")
  f29Must(axlCNSSetPhysical("HI2L_P_USB_AUX" "TOP" 'allow_etch t) "2L layer permission")
  f29Must(axlCNSSetPhysical("HI2L_P_USB_AUX" "BOTTOM" 'allow_etch t) "2L layer permission")
  unless(axlCNSCreate('spacing "HI2L_S_USB_AUX" nil) error("Cannot create2L spacing CSet\n"))
  f29Must(axlCNSSetSpacing("HI2L_S_USB_AUX" nil 'smdpin_line "0.2 MM") "2L explicit spacing value")
  f29Must(axlCNSSetSpacing("HI2L_S_USB_AUX" nil 'line_line "0.2 MM") "2L explicit spacing value")
  f29Must(axlCNSSetSpacing("HI2L_S_USB_AUX" nil 'via_line "0.2 MM") "2L explicit spacing value")
  f29Must(axlCNSSetSpacing("HI2L_S_USB_AUX" nil 'line_shape "0.2 MM") "2L explicit spacing value")
  f29Must(axlCNSSetSpacing("HI2L_S_USB_AUX" nil 'via_shape "0.2 MM") "2L explicit spacing value")
  f29Must(axlCNSSetSpacing("HI2L_S_USB_AUX" nil 'shape_shape "0.2 MM") "2L explicit spacing value")
  nc=axlNetClassCreate("HI2L_USB_AUX_P" 'physical)
  unless(nc error("2L netclass create failed\n"))
  axlDBAddProp(list(nc) list(list("PHYSICAL_CONSTRAINT_SET" "HI2L_P_USB_AUX")))
  net=axlDBFindByName('net "USB_CC1")
  old=axlNetClassGet(net 'physical t)
  when(old fprintf(f "CLASS_REASSIGN net=%L domain=%L old=%L new=%L\n" "USB_CC1" 'physical old->name "HI2L_USB_AUX_P") unless(axlNetClassRemove(old net) error("Cannot remove prior class membership\n")))
  unless(axlNetClassAdd(nc net) error("Cannot bind2L netclass member\n"))
  net=axlDBFindByName('net "USB_CC2")
  old=axlNetClassGet(net 'physical t)
  when(old fprintf(f "CLASS_REASSIGN net=%L domain=%L old=%L new=%L\n" "USB_CC2" 'physical old->name "HI2L_USB_AUX_P") unless(axlNetClassRemove(old net) error("Cannot remove prior class membership\n")))
  unless(axlNetClassAdd(nc net) error("Cannot bind2L netclass member\n"))
  net=axlDBFindByName('net "VBUS_GATE")
  old=axlNetClassGet(net 'physical t)
  when(old fprintf(f "CLASS_REASSIGN net=%L domain=%L old=%L new=%L\n" "VBUS_GATE" 'physical old->name "HI2L_USB_AUX_P") unless(axlNetClassRemove(old net) error("Cannot remove prior class membership\n")))
  unless(axlNetClassAdd(nc net) error("Cannot bind2L netclass member\n"))
  net=axlDBFindByName('net "VBUS_PRESENT_N")
  old=axlNetClassGet(net 'physical t)
  when(old fprintf(f "CLASS_REASSIGN net=%L domain=%L old=%L new=%L\n" "VBUS_PRESENT_N" 'physical old->name "HI2L_USB_AUX_P") unless(axlNetClassRemove(old net) error("Cannot remove prior class membership\n")))
  unless(axlNetClassAdd(nc net) error("Cannot bind2L netclass member\n"))
  net=axlDBFindByName('net "USB_ATTACH_N")
  old=axlNetClassGet(net 'physical t)
  when(old fprintf(f "CLASS_REASSIGN net=%L domain=%L old=%L new=%L\n" "USB_ATTACH_N" 'physical old->name "HI2L_USB_AUX_P") unless(axlNetClassRemove(old net) error("Cannot remove prior class membership\n")))
  unless(axlNetClassAdd(nc net) error("Cannot bind2L netclass member\n"))
  net=axlDBFindByName('net "USB_PULLUP_SRC")
  old=axlNetClassGet(net 'physical t)
  when(old fprintf(f "CLASS_REASSIGN net=%L domain=%L old=%L new=%L\n" "USB_PULLUP_SRC" 'physical old->name "HI2L_USB_AUX_P") unless(axlNetClassRemove(old net) error("Cannot remove prior class membership\n")))
  unless(axlNetClassAdd(nc net) error("Cannot bind2L netclass member\n"))
  nc=axlNetClassCreate("HI2L_USB_AUX_S" 'spacing)
  unless(nc error("2L netclass create failed\n"))
  axlDBAddProp(list(nc) list(list("SPACING_CONSTRAINT_SET" "HI2L_S_USB_AUX")))
  net=axlDBFindByName('net "USB_CC1")
  old=axlNetClassGet(net 'spacing t)
  when(old fprintf(f "CLASS_REASSIGN net=%L domain=%L old=%L new=%L\n" "USB_CC1" 'spacing old->name "HI2L_USB_AUX_S") unless(axlNetClassRemove(old net) error("Cannot remove prior class membership\n")))
  unless(axlNetClassAdd(nc net) error("Cannot bind2L netclass member\n"))
  net=axlDBFindByName('net "USB_CC2")
  old=axlNetClassGet(net 'spacing t)
  when(old fprintf(f "CLASS_REASSIGN net=%L domain=%L old=%L new=%L\n" "USB_CC2" 'spacing old->name "HI2L_USB_AUX_S") unless(axlNetClassRemove(old net) error("Cannot remove prior class membership\n")))
  unless(axlNetClassAdd(nc net) error("Cannot bind2L netclass member\n"))
  net=axlDBFindByName('net "VBUS_GATE")
  old=axlNetClassGet(net 'spacing t)
  when(old fprintf(f "CLASS_REASSIGN net=%L domain=%L old=%L new=%L\n" "VBUS_GATE" 'spacing old->name "HI2L_USB_AUX_S") unless(axlNetClassRemove(old net) error("Cannot remove prior class membership\n")))
  unless(axlNetClassAdd(nc net) error("Cannot bind2L netclass member\n"))
  net=axlDBFindByName('net "VBUS_PRESENT_N")
  old=axlNetClassGet(net 'spacing t)
  when(old fprintf(f "CLASS_REASSIGN net=%L domain=%L old=%L new=%L\n" "VBUS_PRESENT_N" 'spacing old->name "HI2L_USB_AUX_S") unless(axlNetClassRemove(old net) error("Cannot remove prior class membership\n")))
  unless(axlNetClassAdd(nc net) error("Cannot bind2L netclass member\n"))
  net=axlDBFindByName('net "USB_ATTACH_N")
  old=axlNetClassGet(net 'spacing t)
  when(old fprintf(f "CLASS_REASSIGN net=%L domain=%L old=%L new=%L\n" "USB_ATTACH_N" 'spacing old->name "HI2L_USB_AUX_S") unless(axlNetClassRemove(old net) error("Cannot remove prior class membership\n")))
  unless(axlNetClassAdd(nc net) error("Cannot bind2L netclass member\n"))
  net=axlDBFindByName('net "USB_PULLUP_SRC")
  old=axlNetClassGet(net 'spacing t)
  when(old fprintf(f "CLASS_REASSIGN net=%L domain=%L old=%L new=%L\n" "USB_PULLUP_SRC" 'spacing old->name "HI2L_USB_AUX_S") unless(axlNetClassRemove(old net) error("Cannot remove prior class membership\n")))
  unless(axlNetClassAdd(nc net) error("Cannot bind2L netclass member\n"))
  nc=axlNetClassCreate("HI2L_USB_AUX_E" 'electrical)
  unless(nc error("2L netclass create failed\n"))
  net=axlDBFindByName('net "USB_CC1")
  old=axlNetClassGet(net 'electrical t)
  when(old fprintf(f "CLASS_REASSIGN net=%L domain=%L old=%L new=%L\n" "USB_CC1" 'electrical old->name "HI2L_USB_AUX_E") unless(axlNetClassRemove(old net) error("Cannot remove prior class membership\n")))
  unless(axlNetClassAdd(nc net) error("Cannot bind2L netclass member\n"))
  net=axlDBFindByName('net "USB_CC2")
  old=axlNetClassGet(net 'electrical t)
  when(old fprintf(f "CLASS_REASSIGN net=%L domain=%L old=%L new=%L\n" "USB_CC2" 'electrical old->name "HI2L_USB_AUX_E") unless(axlNetClassRemove(old net) error("Cannot remove prior class membership\n")))
  unless(axlNetClassAdd(nc net) error("Cannot bind2L netclass member\n"))
  net=axlDBFindByName('net "VBUS_GATE")
  old=axlNetClassGet(net 'electrical t)
  when(old fprintf(f "CLASS_REASSIGN net=%L domain=%L old=%L new=%L\n" "VBUS_GATE" 'electrical old->name "HI2L_USB_AUX_E") unless(axlNetClassRemove(old net) error("Cannot remove prior class membership\n")))
  unless(axlNetClassAdd(nc net) error("Cannot bind2L netclass member\n"))
  net=axlDBFindByName('net "VBUS_PRESENT_N")
  old=axlNetClassGet(net 'electrical t)
  when(old fprintf(f "CLASS_REASSIGN net=%L domain=%L old=%L new=%L\n" "VBUS_PRESENT_N" 'electrical old->name "HI2L_USB_AUX_E") unless(axlNetClassRemove(old net) error("Cannot remove prior class membership\n")))
  unless(axlNetClassAdd(nc net) error("Cannot bind2L netclass member\n"))
  net=axlDBFindByName('net "USB_ATTACH_N")
  old=axlNetClassGet(net 'electrical t)
  when(old fprintf(f "CLASS_REASSIGN net=%L domain=%L old=%L new=%L\n" "USB_ATTACH_N" 'electrical old->name "HI2L_USB_AUX_E") unless(axlNetClassRemove(old net) error("Cannot remove prior class membership\n")))
  unless(axlNetClassAdd(nc net) error("Cannot bind2L netclass member\n"))
  net=axlDBFindByName('net "USB_PULLUP_SRC")
  old=axlNetClassGet(net 'electrical t)
  when(old fprintf(f "CLASS_REASSIGN net=%L domain=%L old=%L new=%L\n" "USB_PULLUP_SRC" 'electrical old->name "HI2L_USB_AUX_E") unless(axlNetClassRemove(old net) error("Cannot remove prior class membership\n")))
  unless(axlNetClassAdd(nc net) error("Cannot bind2L netclass member\n"))
  unless(axlCNSCreate('physical "HI2L_P_RESET_BOOT_SWD" nil) error("Cannot create2L physical CSet\n"))
  f29Must(axlCNSSetPhysical("HI2L_P_RESET_BOOT_SWD" nil 'width_min "0.2 MM") "2L specific physical value")
  f29Must(axlCNSSetPhysical("HI2L_P_RESET_BOOT_SWD" nil 'neckwidth_min "0.16 MM") "2L specific physical value")
  f29Must(axlCNSSetPhysical("HI2L_P_RESET_BOOT_SWD" nil 'necklength_max "1.0 MM") "2L specific physical value")
  f29Must(axlCNSSetPhysical("HI2L_P_RESET_BOOT_SWD" nil 'vias "L28_VIA030_C060") "Approved2L via")
  f29Must(axlCNSSetPhysical("HI2L_P_RESET_BOOT_SWD" "TOP" 'allow_etch t) "2L layer permission")
  f29Must(axlCNSSetPhysical("HI2L_P_RESET_BOOT_SWD" "BOTTOM" 'allow_etch t) "2L layer permission")
  unless(axlCNSCreate('spacing "HI2L_S_RESET_BOOT_SWD" nil) error("Cannot create2L spacing CSet\n"))
  f29Must(axlCNSSetSpacing("HI2L_S_RESET_BOOT_SWD" nil 'smdpin_line "0.2 MM") "2L explicit spacing value")
  f29Must(axlCNSSetSpacing("HI2L_S_RESET_BOOT_SWD" nil 'line_line "0.2 MM") "2L explicit spacing value")
  f29Must(axlCNSSetSpacing("HI2L_S_RESET_BOOT_SWD" nil 'via_line "0.2 MM") "2L explicit spacing value")
  f29Must(axlCNSSetSpacing("HI2L_S_RESET_BOOT_SWD" nil 'line_shape "0.2 MM") "2L explicit spacing value")
  f29Must(axlCNSSetSpacing("HI2L_S_RESET_BOOT_SWD" nil 'via_shape "0.2 MM") "2L explicit spacing value")
  f29Must(axlCNSSetSpacing("HI2L_S_RESET_BOOT_SWD" nil 'shape_shape "0.2 MM") "2L explicit spacing value")
  nc=axlNetClassCreate("HI2L_RESET_BOOT_SWD_P" 'physical)
  unless(nc error("2L netclass create failed\n"))
  axlDBAddProp(list(nc) list(list("PHYSICAL_CONSTRAINT_SET" "HI2L_P_RESET_BOOT_SWD")))
  net=axlDBFindByName('net "NRST")
  old=axlNetClassGet(net 'physical t)
  when(old fprintf(f "CLASS_REASSIGN net=%L domain=%L old=%L new=%L\n" "NRST" 'physical old->name "HI2L_RESET_BOOT_SWD_P") unless(axlNetClassRemove(old net) error("Cannot remove prior class membership\n")))
  unless(axlNetClassAdd(nc net) error("Cannot bind2L netclass member\n"))
  net=axlDBFindByName('net "BOOT0")
  old=axlNetClassGet(net 'physical t)
  when(old fprintf(f "CLASS_REASSIGN net=%L domain=%L old=%L new=%L\n" "BOOT0" 'physical old->name "HI2L_RESET_BOOT_SWD_P") unless(axlNetClassRemove(old net) error("Cannot remove prior class membership\n")))
  unless(axlNetClassAdd(nc net) error("Cannot bind2L netclass member\n"))
  net=axlDBFindByName('net "BOOT1")
  old=axlNetClassGet(net 'physical t)
  when(old fprintf(f "CLASS_REASSIGN net=%L domain=%L old=%L new=%L\n" "BOOT1" 'physical old->name "HI2L_RESET_BOOT_SWD_P") unless(axlNetClassRemove(old net) error("Cannot remove prior class membership\n")))
  unless(axlNetClassAdd(nc net) error("Cannot bind2L netclass member\n"))
  net=axlDBFindByName('net "BOOT_SERVICE")
  old=axlNetClassGet(net 'physical t)
  when(old fprintf(f "CLASS_REASSIGN net=%L domain=%L old=%L new=%L\n" "BOOT_SERVICE" 'physical old->name "HI2L_RESET_BOOT_SWD_P") unless(axlNetClassRemove(old net) error("Cannot remove prior class membership\n")))
  unless(axlNetClassAdd(nc net) error("Cannot bind2L netclass member\n"))
  net=axlDBFindByName('net "SWDIO")
  old=axlNetClassGet(net 'physical t)
  when(old fprintf(f "CLASS_REASSIGN net=%L domain=%L old=%L new=%L\n" "SWDIO" 'physical old->name "HI2L_RESET_BOOT_SWD_P") unless(axlNetClassRemove(old net) error("Cannot remove prior class membership\n")))
  unless(axlNetClassAdd(nc net) error("Cannot bind2L netclass member\n"))
  net=axlDBFindByName('net "SWCLK")
  old=axlNetClassGet(net 'physical t)
  when(old fprintf(f "CLASS_REASSIGN net=%L domain=%L old=%L new=%L\n" "SWCLK" 'physical old->name "HI2L_RESET_BOOT_SWD_P") unless(axlNetClassRemove(old net) error("Cannot remove prior class membership\n")))
  unless(axlNetClassAdd(nc net) error("Cannot bind2L netclass member\n"))
  net=axlDBFindByName('net "SWO")
  old=axlNetClassGet(net 'physical t)
  when(old fprintf(f "CLASS_REASSIGN net=%L domain=%L old=%L new=%L\n" "SWO" 'physical old->name "HI2L_RESET_BOOT_SWD_P") unless(axlNetClassRemove(old net) error("Cannot remove prior class membership\n")))
  unless(axlNetClassAdd(nc net) error("Cannot bind2L netclass member\n"))
  nc=axlNetClassCreate("HI2L_RESET_BOOT_SWD_S" 'spacing)
  unless(nc error("2L netclass create failed\n"))
  axlDBAddProp(list(nc) list(list("SPACING_CONSTRAINT_SET" "HI2L_S_RESET_BOOT_SWD")))
  net=axlDBFindByName('net "NRST")
  old=axlNetClassGet(net 'spacing t)
  when(old fprintf(f "CLASS_REASSIGN net=%L domain=%L old=%L new=%L\n" "NRST" 'spacing old->name "HI2L_RESET_BOOT_SWD_S") unless(axlNetClassRemove(old net) error("Cannot remove prior class membership\n")))
  unless(axlNetClassAdd(nc net) error("Cannot bind2L netclass member\n"))
  net=axlDBFindByName('net "BOOT0")
  old=axlNetClassGet(net 'spacing t)
  when(old fprintf(f "CLASS_REASSIGN net=%L domain=%L old=%L new=%L\n" "BOOT0" 'spacing old->name "HI2L_RESET_BOOT_SWD_S") unless(axlNetClassRemove(old net) error("Cannot remove prior class membership\n")))
  unless(axlNetClassAdd(nc net) error("Cannot bind2L netclass member\n"))
  net=axlDBFindByName('net "BOOT1")
  old=axlNetClassGet(net 'spacing t)
  when(old fprintf(f "CLASS_REASSIGN net=%L domain=%L old=%L new=%L\n" "BOOT1" 'spacing old->name "HI2L_RESET_BOOT_SWD_S") unless(axlNetClassRemove(old net) error("Cannot remove prior class membership\n")))
  unless(axlNetClassAdd(nc net) error("Cannot bind2L netclass member\n"))
  net=axlDBFindByName('net "BOOT_SERVICE")
  old=axlNetClassGet(net 'spacing t)
  when(old fprintf(f "CLASS_REASSIGN net=%L domain=%L old=%L new=%L\n" "BOOT_SERVICE" 'spacing old->name "HI2L_RESET_BOOT_SWD_S") unless(axlNetClassRemove(old net) error("Cannot remove prior class membership\n")))
  unless(axlNetClassAdd(nc net) error("Cannot bind2L netclass member\n"))
  net=axlDBFindByName('net "SWDIO")
  old=axlNetClassGet(net 'spacing t)
  when(old fprintf(f "CLASS_REASSIGN net=%L domain=%L old=%L new=%L\n" "SWDIO" 'spacing old->name "HI2L_RESET_BOOT_SWD_S") unless(axlNetClassRemove(old net) error("Cannot remove prior class membership\n")))
  unless(axlNetClassAdd(nc net) error("Cannot bind2L netclass member\n"))
  net=axlDBFindByName('net "SWCLK")
  old=axlNetClassGet(net 'spacing t)
  when(old fprintf(f "CLASS_REASSIGN net=%L domain=%L old=%L new=%L\n" "SWCLK" 'spacing old->name "HI2L_RESET_BOOT_SWD_S") unless(axlNetClassRemove(old net) error("Cannot remove prior class membership\n")))
  unless(axlNetClassAdd(nc net) error("Cannot bind2L netclass member\n"))
  net=axlDBFindByName('net "SWO")
  old=axlNetClassGet(net 'spacing t)
  when(old fprintf(f "CLASS_REASSIGN net=%L domain=%L old=%L new=%L\n" "SWO" 'spacing old->name "HI2L_RESET_BOOT_SWD_S") unless(axlNetClassRemove(old net) error("Cannot remove prior class membership\n")))
  unless(axlNetClassAdd(nc net) error("Cannot bind2L netclass member\n"))
  nc=axlNetClassCreate("HI2L_RESET_BOOT_SWD_E" 'electrical)
  unless(nc error("2L netclass create failed\n"))
  net=axlDBFindByName('net "NRST")
  old=axlNetClassGet(net 'electrical t)
  when(old fprintf(f "CLASS_REASSIGN net=%L domain=%L old=%L new=%L\n" "NRST" 'electrical old->name "HI2L_RESET_BOOT_SWD_E") unless(axlNetClassRemove(old net) error("Cannot remove prior class membership\n")))
  unless(axlNetClassAdd(nc net) error("Cannot bind2L netclass member\n"))
  net=axlDBFindByName('net "BOOT0")
  old=axlNetClassGet(net 'electrical t)
  when(old fprintf(f "CLASS_REASSIGN net=%L domain=%L old=%L new=%L\n" "BOOT0" 'electrical old->name "HI2L_RESET_BOOT_SWD_E") unless(axlNetClassRemove(old net) error("Cannot remove prior class membership\n")))
  unless(axlNetClassAdd(nc net) error("Cannot bind2L netclass member\n"))
  net=axlDBFindByName('net "BOOT1")
  old=axlNetClassGet(net 'electrical t)
  when(old fprintf(f "CLASS_REASSIGN net=%L domain=%L old=%L new=%L\n" "BOOT1" 'electrical old->name "HI2L_RESET_BOOT_SWD_E") unless(axlNetClassRemove(old net) error("Cannot remove prior class membership\n")))
  unless(axlNetClassAdd(nc net) error("Cannot bind2L netclass member\n"))
  net=axlDBFindByName('net "BOOT_SERVICE")
  old=axlNetClassGet(net 'electrical t)
  when(old fprintf(f "CLASS_REASSIGN net=%L domain=%L old=%L new=%L\n" "BOOT_SERVICE" 'electrical old->name "HI2L_RESET_BOOT_SWD_E") unless(axlNetClassRemove(old net) error("Cannot remove prior class membership\n")))
  unless(axlNetClassAdd(nc net) error("Cannot bind2L netclass member\n"))
  net=axlDBFindByName('net "SWDIO")
  old=axlNetClassGet(net 'electrical t)
  when(old fprintf(f "CLASS_REASSIGN net=%L domain=%L old=%L new=%L\n" "SWDIO" 'electrical old->name "HI2L_RESET_BOOT_SWD_E") unless(axlNetClassRemove(old net) error("Cannot remove prior class membership\n")))
  unless(axlNetClassAdd(nc net) error("Cannot bind2L netclass member\n"))
  net=axlDBFindByName('net "SWCLK")
  old=axlNetClassGet(net 'electrical t)
  when(old fprintf(f "CLASS_REASSIGN net=%L domain=%L old=%L new=%L\n" "SWCLK" 'electrical old->name "HI2L_RESET_BOOT_SWD_E") unless(axlNetClassRemove(old net) error("Cannot remove prior class membership\n")))
  unless(axlNetClassAdd(nc net) error("Cannot bind2L netclass member\n"))
  net=axlDBFindByName('net "SWO")
  old=axlNetClassGet(net 'electrical t)
  when(old fprintf(f "CLASS_REASSIGN net=%L domain=%L old=%L new=%L\n" "SWO" 'electrical old->name "HI2L_RESET_BOOT_SWD_E") unless(axlNetClassRemove(old net) error("Cannot remove prior class membership\n")))
  unless(axlNetClassAdd(nc net) error("Cannot bind2L netclass member\n"))
  unless(axlCNSCreate('physical "HI2L_P_I2C" nil) error("Cannot create2L physical CSet\n"))
  f29Must(axlCNSSetPhysical("HI2L_P_I2C" nil 'width_min "0.2 MM") "2L specific physical value")
  f29Must(axlCNSSetPhysical("HI2L_P_I2C" nil 'neckwidth_min "0.16 MM") "2L specific physical value")
  f29Must(axlCNSSetPhysical("HI2L_P_I2C" nil 'necklength_max "1.0 MM") "2L specific physical value")
  f29Must(axlCNSSetPhysical("HI2L_P_I2C" nil 'vias "L28_VIA030_C060") "Approved2L via")
  f29Must(axlCNSSetPhysical("HI2L_P_I2C" "TOP" 'allow_etch t) "2L layer permission")
  f29Must(axlCNSSetPhysical("HI2L_P_I2C" "BOTTOM" 'allow_etch t) "2L layer permission")
  unless(axlCNSCreate('spacing "HI2L_S_I2C" nil) error("Cannot create2L spacing CSet\n"))
  f29Must(axlCNSSetSpacing("HI2L_S_I2C" nil 'smdpin_line "0.2 MM") "2L explicit spacing value")
  f29Must(axlCNSSetSpacing("HI2L_S_I2C" nil 'line_line "0.2 MM") "2L explicit spacing value")
  f29Must(axlCNSSetSpacing("HI2L_S_I2C" nil 'via_line "0.2 MM") "2L explicit spacing value")
  f29Must(axlCNSSetSpacing("HI2L_S_I2C" nil 'line_shape "0.2 MM") "2L explicit spacing value")
  f29Must(axlCNSSetSpacing("HI2L_S_I2C" nil 'via_shape "0.2 MM") "2L explicit spacing value")
  f29Must(axlCNSSetSpacing("HI2L_S_I2C" nil 'shape_shape "0.2 MM") "2L explicit spacing value")
  nc=axlNetClassCreate("HI2L_I2C_P" 'physical)
  unless(nc error("2L netclass create failed\n"))
  axlDBAddProp(list(nc) list(list("PHYSICAL_CONSTRAINT_SET" "HI2L_P_I2C")))
  net=axlDBFindByName('net "I2C_SCL")
  old=axlNetClassGet(net 'physical t)
  when(old fprintf(f "CLASS_REASSIGN net=%L domain=%L old=%L new=%L\n" "I2C_SCL" 'physical old->name "HI2L_I2C_P") unless(axlNetClassRemove(old net) error("Cannot remove prior class membership\n")))
  unless(axlNetClassAdd(nc net) error("Cannot bind2L netclass member\n"))
  net=axlDBFindByName('net "I2C_SDA")
  old=axlNetClassGet(net 'physical t)
  when(old fprintf(f "CLASS_REASSIGN net=%L domain=%L old=%L new=%L\n" "I2C_SDA" 'physical old->name "HI2L_I2C_P") unless(axlNetClassRemove(old net) error("Cannot remove prior class membership\n")))
  unless(axlNetClassAdd(nc net) error("Cannot bind2L netclass member\n"))
  nc=axlNetClassCreate("HI2L_I2C_S" 'spacing)
  unless(nc error("2L netclass create failed\n"))
  axlDBAddProp(list(nc) list(list("SPACING_CONSTRAINT_SET" "HI2L_S_I2C")))
  net=axlDBFindByName('net "I2C_SCL")
  old=axlNetClassGet(net 'spacing t)
  when(old fprintf(f "CLASS_REASSIGN net=%L domain=%L old=%L new=%L\n" "I2C_SCL" 'spacing old->name "HI2L_I2C_S") unless(axlNetClassRemove(old net) error("Cannot remove prior class membership\n")))
  unless(axlNetClassAdd(nc net) error("Cannot bind2L netclass member\n"))
  net=axlDBFindByName('net "I2C_SDA")
  old=axlNetClassGet(net 'spacing t)
  when(old fprintf(f "CLASS_REASSIGN net=%L domain=%L old=%L new=%L\n" "I2C_SDA" 'spacing old->name "HI2L_I2C_S") unless(axlNetClassRemove(old net) error("Cannot remove prior class membership\n")))
  unless(axlNetClassAdd(nc net) error("Cannot bind2L netclass member\n"))
  nc=axlNetClassCreate("HI2L_I2C_E" 'electrical)
  unless(nc error("2L netclass create failed\n"))
  net=axlDBFindByName('net "I2C_SCL")
  old=axlNetClassGet(net 'electrical t)
  when(old fprintf(f "CLASS_REASSIGN net=%L domain=%L old=%L new=%L\n" "I2C_SCL" 'electrical old->name "HI2L_I2C_E") unless(axlNetClassRemove(old net) error("Cannot remove prior class membership\n")))
  unless(axlNetClassAdd(nc net) error("Cannot bind2L netclass member\n"))
  net=axlDBFindByName('net "I2C_SDA")
  old=axlNetClassGet(net 'electrical t)
  when(old fprintf(f "CLASS_REASSIGN net=%L domain=%L old=%L new=%L\n" "I2C_SDA" 'electrical old->name "HI2L_I2C_E") unless(axlNetClassRemove(old net) error("Cannot remove prior class membership\n")))
  unless(axlNetClassAdd(nc net) error("Cannot bind2L netclass member\n"))
  unless(axlCNSCreate('physical "HI2L_P_SPI" nil) error("Cannot create2L physical CSet\n"))
  f29Must(axlCNSSetPhysical("HI2L_P_SPI" nil 'width_min "0.2 MM") "2L specific physical value")
  f29Must(axlCNSSetPhysical("HI2L_P_SPI" nil 'neckwidth_min "0.16 MM") "2L specific physical value")
  f29Must(axlCNSSetPhysical("HI2L_P_SPI" nil 'necklength_max "1.0 MM") "2L specific physical value")
  f29Must(axlCNSSetPhysical("HI2L_P_SPI" nil 'vias "L28_VIA030_C060") "Approved2L via")
  f29Must(axlCNSSetPhysical("HI2L_P_SPI" "TOP" 'allow_etch t) "2L layer permission")
  f29Must(axlCNSSetPhysical("HI2L_P_SPI" "BOTTOM" 'allow_etch t) "2L layer permission")
  unless(axlCNSCreate('spacing "HI2L_S_SPI" nil) error("Cannot create2L spacing CSet\n"))
  f29Must(axlCNSSetSpacing("HI2L_S_SPI" nil 'smdpin_line "0.2 MM") "2L explicit spacing value")
  f29Must(axlCNSSetSpacing("HI2L_S_SPI" nil 'line_line "0.2 MM") "2L explicit spacing value")
  f29Must(axlCNSSetSpacing("HI2L_S_SPI" nil 'via_line "0.2 MM") "2L explicit spacing value")
  f29Must(axlCNSSetSpacing("HI2L_S_SPI" nil 'line_shape "0.2 MM") "2L explicit spacing value")
  f29Must(axlCNSSetSpacing("HI2L_S_SPI" nil 'via_shape "0.2 MM") "2L explicit spacing value")
  f29Must(axlCNSSetSpacing("HI2L_S_SPI" nil 'shape_shape "0.2 MM") "2L explicit spacing value")
  nc=axlNetClassCreate("HI2L_SPI_P" 'physical)
  unless(nc error("2L netclass create failed\n"))
  axlDBAddProp(list(nc) list(list("PHYSICAL_CONSTRAINT_SET" "HI2L_P_SPI")))
  net=axlDBFindByName('net "PA4_SPI_NSS")
  old=axlNetClassGet(net 'physical t)
  when(old fprintf(f "CLASS_REASSIGN net=%L domain=%L old=%L new=%L\n" "PA4_SPI_NSS" 'physical old->name "HI2L_SPI_P") unless(axlNetClassRemove(old net) error("Cannot remove prior class membership\n")))
  unless(axlNetClassAdd(nc net) error("Cannot bind2L netclass member\n"))
  net=axlDBFindByName('net "PA5_SPI_SCK")
  old=axlNetClassGet(net 'physical t)
  when(old fprintf(f "CLASS_REASSIGN net=%L domain=%L old=%L new=%L\n" "PA5_SPI_SCK" 'physical old->name "HI2L_SPI_P") unless(axlNetClassRemove(old net) error("Cannot remove prior class membership\n")))
  unless(axlNetClassAdd(nc net) error("Cannot bind2L netclass member\n"))
  net=axlDBFindByName('net "PA6_SPI_MISO")
  old=axlNetClassGet(net 'physical t)
  when(old fprintf(f "CLASS_REASSIGN net=%L domain=%L old=%L new=%L\n" "PA6_SPI_MISO" 'physical old->name "HI2L_SPI_P") unless(axlNetClassRemove(old net) error("Cannot remove prior class membership\n")))
  unless(axlNetClassAdd(nc net) error("Cannot bind2L netclass member\n"))
  net=axlDBFindByName('net "PA7_SPI_MOSI")
  old=axlNetClassGet(net 'physical t)
  when(old fprintf(f "CLASS_REASSIGN net=%L domain=%L old=%L new=%L\n" "PA7_SPI_MOSI" 'physical old->name "HI2L_SPI_P") unless(axlNetClassRemove(old net) error("Cannot remove prior class membership\n")))
  unless(axlNetClassAdd(nc net) error("Cannot bind2L netclass member\n"))
  net=axlDBFindByName('net "SPI_NSS")
  old=axlNetClassGet(net 'physical t)
  when(old fprintf(f "CLASS_REASSIGN net=%L domain=%L old=%L new=%L\n" "SPI_NSS" 'physical old->name "HI2L_SPI_P") unless(axlNetClassRemove(old net) error("Cannot remove prior class membership\n")))
  unless(axlNetClassAdd(nc net) error("Cannot bind2L netclass member\n"))
  net=axlDBFindByName('net "SPI_SCK")
  old=axlNetClassGet(net 'physical t)
  when(old fprintf(f "CLASS_REASSIGN net=%L domain=%L old=%L new=%L\n" "SPI_SCK" 'physical old->name "HI2L_SPI_P") unless(axlNetClassRemove(old net) error("Cannot remove prior class membership\n")))
  unless(axlNetClassAdd(nc net) error("Cannot bind2L netclass member\n"))
  net=axlDBFindByName('net "SPI_MISO")
  old=axlNetClassGet(net 'physical t)
  when(old fprintf(f "CLASS_REASSIGN net=%L domain=%L old=%L new=%L\n" "SPI_MISO" 'physical old->name "HI2L_SPI_P") unless(axlNetClassRemove(old net) error("Cannot remove prior class membership\n")))
  unless(axlNetClassAdd(nc net) error("Cannot bind2L netclass member\n"))
  net=axlDBFindByName('net "SPI_MOSI")
  old=axlNetClassGet(net 'physical t)
  when(old fprintf(f "CLASS_REASSIGN net=%L domain=%L old=%L new=%L\n" "SPI_MOSI" 'physical old->name "HI2L_SPI_P") unless(axlNetClassRemove(old net) error("Cannot remove prior class membership\n")))
  unless(axlNetClassAdd(nc net) error("Cannot bind2L netclass member\n"))
  nc=axlNetClassCreate("HI2L_SPI_S" 'spacing)
  unless(nc error("2L netclass create failed\n"))
  axlDBAddProp(list(nc) list(list("SPACING_CONSTRAINT_SET" "HI2L_S_SPI")))
  net=axlDBFindByName('net "PA4_SPI_NSS")
  old=axlNetClassGet(net 'spacing t)
  when(old fprintf(f "CLASS_REASSIGN net=%L domain=%L old=%L new=%L\n" "PA4_SPI_NSS" 'spacing old->name "HI2L_SPI_S") unless(axlNetClassRemove(old net) error("Cannot remove prior class membership\n")))
  unless(axlNetClassAdd(nc net) error("Cannot bind2L netclass member\n"))
  net=axlDBFindByName('net "PA5_SPI_SCK")
  old=axlNetClassGet(net 'spacing t)
  when(old fprintf(f "CLASS_REASSIGN net=%L domain=%L old=%L new=%L\n" "PA5_SPI_SCK" 'spacing old->name "HI2L_SPI_S") unless(axlNetClassRemove(old net) error("Cannot remove prior class membership\n")))
  unless(axlNetClassAdd(nc net) error("Cannot bind2L netclass member\n"))
  net=axlDBFindByName('net "PA6_SPI_MISO")
  old=axlNetClassGet(net 'spacing t)
  when(old fprintf(f "CLASS_REASSIGN net=%L domain=%L old=%L new=%L\n" "PA6_SPI_MISO" 'spacing old->name "HI2L_SPI_S") unless(axlNetClassRemove(old net) error("Cannot remove prior class membership\n")))
  unless(axlNetClassAdd(nc net) error("Cannot bind2L netclass member\n"))
  net=axlDBFindByName('net "PA7_SPI_MOSI")
  old=axlNetClassGet(net 'spacing t)
  when(old fprintf(f "CLASS_REASSIGN net=%L domain=%L old=%L new=%L\n" "PA7_SPI_MOSI" 'spacing old->name "HI2L_SPI_S") unless(axlNetClassRemove(old net) error("Cannot remove prior class membership\n")))
  unless(axlNetClassAdd(nc net) error("Cannot bind2L netclass member\n"))
  net=axlDBFindByName('net "SPI_NSS")
  old=axlNetClassGet(net 'spacing t)
  when(old fprintf(f "CLASS_REASSIGN net=%L domain=%L old=%L new=%L\n" "SPI_NSS" 'spacing old->name "HI2L_SPI_S") unless(axlNetClassRemove(old net) error("Cannot remove prior class membership\n")))
  unless(axlNetClassAdd(nc net) error("Cannot bind2L netclass member\n"))
  net=axlDBFindByName('net "SPI_SCK")
  old=axlNetClassGet(net 'spacing t)
  when(old fprintf(f "CLASS_REASSIGN net=%L domain=%L old=%L new=%L\n" "SPI_SCK" 'spacing old->name "HI2L_SPI_S") unless(axlNetClassRemove(old net) error("Cannot remove prior class membership\n")))
  unless(axlNetClassAdd(nc net) error("Cannot bind2L netclass member\n"))
  net=axlDBFindByName('net "SPI_MISO")
  old=axlNetClassGet(net 'spacing t)
  when(old fprintf(f "CLASS_REASSIGN net=%L domain=%L old=%L new=%L\n" "SPI_MISO" 'spacing old->name "HI2L_SPI_S") unless(axlNetClassRemove(old net) error("Cannot remove prior class membership\n")))
  unless(axlNetClassAdd(nc net) error("Cannot bind2L netclass member\n"))
  net=axlDBFindByName('net "SPI_MOSI")
  old=axlNetClassGet(net 'spacing t)
  when(old fprintf(f "CLASS_REASSIGN net=%L domain=%L old=%L new=%L\n" "SPI_MOSI" 'spacing old->name "HI2L_SPI_S") unless(axlNetClassRemove(old net) error("Cannot remove prior class membership\n")))
  unless(axlNetClassAdd(nc net) error("Cannot bind2L netclass member\n"))
  nc=axlNetClassCreate("HI2L_SPI_E" 'electrical)
  unless(nc error("2L netclass create failed\n"))
  net=axlDBFindByName('net "PA4_SPI_NSS")
  old=axlNetClassGet(net 'electrical t)
  when(old fprintf(f "CLASS_REASSIGN net=%L domain=%L old=%L new=%L\n" "PA4_SPI_NSS" 'electrical old->name "HI2L_SPI_E") unless(axlNetClassRemove(old net) error("Cannot remove prior class membership\n")))
  unless(axlNetClassAdd(nc net) error("Cannot bind2L netclass member\n"))
  net=axlDBFindByName('net "PA5_SPI_SCK")
  old=axlNetClassGet(net 'electrical t)
  when(old fprintf(f "CLASS_REASSIGN net=%L domain=%L old=%L new=%L\n" "PA5_SPI_SCK" 'electrical old->name "HI2L_SPI_E") unless(axlNetClassRemove(old net) error("Cannot remove prior class membership\n")))
  unless(axlNetClassAdd(nc net) error("Cannot bind2L netclass member\n"))
  net=axlDBFindByName('net "PA6_SPI_MISO")
  old=axlNetClassGet(net 'electrical t)
  when(old fprintf(f "CLASS_REASSIGN net=%L domain=%L old=%L new=%L\n" "PA6_SPI_MISO" 'electrical old->name "HI2L_SPI_E") unless(axlNetClassRemove(old net) error("Cannot remove prior class membership\n")))
  unless(axlNetClassAdd(nc net) error("Cannot bind2L netclass member\n"))
  net=axlDBFindByName('net "PA7_SPI_MOSI")
  old=axlNetClassGet(net 'electrical t)
  when(old fprintf(f "CLASS_REASSIGN net=%L domain=%L old=%L new=%L\n" "PA7_SPI_MOSI" 'electrical old->name "HI2L_SPI_E") unless(axlNetClassRemove(old net) error("Cannot remove prior class membership\n")))
  unless(axlNetClassAdd(nc net) error("Cannot bind2L netclass member\n"))
  net=axlDBFindByName('net "SPI_NSS")
  old=axlNetClassGet(net 'electrical t)
  when(old fprintf(f "CLASS_REASSIGN net=%L domain=%L old=%L new=%L\n" "SPI_NSS" 'electrical old->name "HI2L_SPI_E") unless(axlNetClassRemove(old net) error("Cannot remove prior class membership\n")))
  unless(axlNetClassAdd(nc net) error("Cannot bind2L netclass member\n"))
  net=axlDBFindByName('net "SPI_SCK")
  old=axlNetClassGet(net 'electrical t)
  when(old fprintf(f "CLASS_REASSIGN net=%L domain=%L old=%L new=%L\n" "SPI_SCK" 'electrical old->name "HI2L_SPI_E") unless(axlNetClassRemove(old net) error("Cannot remove prior class membership\n")))
  unless(axlNetClassAdd(nc net) error("Cannot bind2L netclass member\n"))
  net=axlDBFindByName('net "SPI_MISO")
  old=axlNetClassGet(net 'electrical t)
  when(old fprintf(f "CLASS_REASSIGN net=%L domain=%L old=%L new=%L\n" "SPI_MISO" 'electrical old->name "HI2L_SPI_E") unless(axlNetClassRemove(old net) error("Cannot remove prior class membership\n")))
  unless(axlNetClassAdd(nc net) error("Cannot bind2L netclass member\n"))
  net=axlDBFindByName('net "SPI_MOSI")
  old=axlNetClassGet(net 'electrical t)
  when(old fprintf(f "CLASS_REASSIGN net=%L domain=%L old=%L new=%L\n" "SPI_MOSI" 'electrical old->name "HI2L_SPI_E") unless(axlNetClassRemove(old net) error("Cannot remove prior class membership\n")))
  unless(axlNetClassAdd(nc net) error("Cannot bind2L netclass member\n"))
  unless(axlCNSCreate('physical "HI2L_P_UART_CAN_DIGITAL" nil) error("Cannot create2L physical CSet\n"))
  f29Must(axlCNSSetPhysical("HI2L_P_UART_CAN_DIGITAL" nil 'width_min "0.2 MM") "2L specific physical value")
  f29Must(axlCNSSetPhysical("HI2L_P_UART_CAN_DIGITAL" nil 'neckwidth_min "0.16 MM") "2L specific physical value")
  f29Must(axlCNSSetPhysical("HI2L_P_UART_CAN_DIGITAL" nil 'necklength_max "1.0 MM") "2L specific physical value")
  f29Must(axlCNSSetPhysical("HI2L_P_UART_CAN_DIGITAL" nil 'vias "L28_VIA030_C060") "Approved2L via")
  f29Must(axlCNSSetPhysical("HI2L_P_UART_CAN_DIGITAL" "TOP" 'allow_etch t) "2L layer permission")
  f29Must(axlCNSSetPhysical("HI2L_P_UART_CAN_DIGITAL" "BOTTOM" 'allow_etch t) "2L layer permission")
  unless(axlCNSCreate('spacing "HI2L_S_UART_CAN_DIGITAL" nil) error("Cannot create2L spacing CSet\n"))
  f29Must(axlCNSSetSpacing("HI2L_S_UART_CAN_DIGITAL" nil 'smdpin_line "0.2 MM") "2L explicit spacing value")
  f29Must(axlCNSSetSpacing("HI2L_S_UART_CAN_DIGITAL" nil 'line_line "0.2 MM") "2L explicit spacing value")
  f29Must(axlCNSSetSpacing("HI2L_S_UART_CAN_DIGITAL" nil 'via_line "0.2 MM") "2L explicit spacing value")
  f29Must(axlCNSSetSpacing("HI2L_S_UART_CAN_DIGITAL" nil 'line_shape "0.2 MM") "2L explicit spacing value")
  f29Must(axlCNSSetSpacing("HI2L_S_UART_CAN_DIGITAL" nil 'via_shape "0.2 MM") "2L explicit spacing value")
  f29Must(axlCNSSetSpacing("HI2L_S_UART_CAN_DIGITAL" nil 'shape_shape "0.2 MM") "2L explicit spacing value")
  nc=axlNetClassCreate("HI2L_UART_CAN_DIGITAL_P" 'physical)
  unless(nc error("2L netclass create failed\n"))
  axlDBAddProp(list(nc) list(list("PHYSICAL_CONSTRAINT_SET" "HI2L_P_UART_CAN_DIGITAL")))
  net=axlDBFindByName('net "PA9_UART_TX")
  old=axlNetClassGet(net 'physical t)
  when(old fprintf(f "CLASS_REASSIGN net=%L domain=%L old=%L new=%L\n" "PA9_UART_TX" 'physical old->name "HI2L_UART_CAN_DIGITAL_P") unless(axlNetClassRemove(old net) error("Cannot remove prior class membership\n")))
  unless(axlNetClassAdd(nc net) error("Cannot bind2L netclass member\n"))
  net=axlDBFindByName('net "PA10_UART_RX")
  old=axlNetClassGet(net 'physical t)
  when(old fprintf(f "CLASS_REASSIGN net=%L domain=%L old=%L new=%L\n" "PA10_UART_RX" 'physical old->name "HI2L_UART_CAN_DIGITAL_P") unless(axlNetClassRemove(old net) error("Cannot remove prior class membership\n")))
  unless(axlNetClassAdd(nc net) error("Cannot bind2L netclass member\n"))
  net=axlDBFindByName('net "UART_TX")
  old=axlNetClassGet(net 'physical t)
  when(old fprintf(f "CLASS_REASSIGN net=%L domain=%L old=%L new=%L\n" "UART_TX" 'physical old->name "HI2L_UART_CAN_DIGITAL_P") unless(axlNetClassRemove(old net) error("Cannot remove prior class membership\n")))
  unless(axlNetClassAdd(nc net) error("Cannot bind2L netclass member\n"))
  net=axlDBFindByName('net "UART_RX")
  old=axlNetClassGet(net 'physical t)
  when(old fprintf(f "CLASS_REASSIGN net=%L domain=%L old=%L new=%L\n" "UART_RX" 'physical old->name "HI2L_UART_CAN_DIGITAL_P") unless(axlNetClassRemove(old net) error("Cannot remove prior class membership\n")))
  unless(axlNetClassAdd(nc net) error("Cannot bind2L netclass member\n"))
  net=axlDBFindByName('net "CAN_TXD")
  old=axlNetClassGet(net 'physical t)
  when(old fprintf(f "CLASS_REASSIGN net=%L domain=%L old=%L new=%L\n" "CAN_TXD" 'physical old->name "HI2L_UART_CAN_DIGITAL_P") unless(axlNetClassRemove(old net) error("Cannot remove prior class membership\n")))
  unless(axlNetClassAdd(nc net) error("Cannot bind2L netclass member\n"))
  net=axlDBFindByName('net "CAN_RXD")
  old=axlNetClassGet(net 'physical t)
  when(old fprintf(f "CLASS_REASSIGN net=%L domain=%L old=%L new=%L\n" "CAN_RXD" 'physical old->name "HI2L_UART_CAN_DIGITAL_P") unless(axlNetClassRemove(old net) error("Cannot remove prior class membership\n")))
  unless(axlNetClassAdd(nc net) error("Cannot bind2L netclass member\n"))
  nc=axlNetClassCreate("HI2L_UART_CAN_DIGITAL_S" 'spacing)
  unless(nc error("2L netclass create failed\n"))
  axlDBAddProp(list(nc) list(list("SPACING_CONSTRAINT_SET" "HI2L_S_UART_CAN_DIGITAL")))
  net=axlDBFindByName('net "PA9_UART_TX")
  old=axlNetClassGet(net 'spacing t)
  when(old fprintf(f "CLASS_REASSIGN net=%L domain=%L old=%L new=%L\n" "PA9_UART_TX" 'spacing old->name "HI2L_UART_CAN_DIGITAL_S") unless(axlNetClassRemove(old net) error("Cannot remove prior class membership\n")))
  unless(axlNetClassAdd(nc net) error("Cannot bind2L netclass member\n"))
  net=axlDBFindByName('net "PA10_UART_RX")
  old=axlNetClassGet(net 'spacing t)
  when(old fprintf(f "CLASS_REASSIGN net=%L domain=%L old=%L new=%L\n" "PA10_UART_RX" 'spacing old->name "HI2L_UART_CAN_DIGITAL_S") unless(axlNetClassRemove(old net) error("Cannot remove prior class membership\n")))
  unless(axlNetClassAdd(nc net) error("Cannot bind2L netclass member\n"))
  net=axlDBFindByName('net "UART_TX")
  old=axlNetClassGet(net 'spacing t)
  when(old fprintf(f "CLASS_REASSIGN net=%L domain=%L old=%L new=%L\n" "UART_TX" 'spacing old->name "HI2L_UART_CAN_DIGITAL_S") unless(axlNetClassRemove(old net) error("Cannot remove prior class membership\n")))
  unless(axlNetClassAdd(nc net) error("Cannot bind2L netclass member\n"))
  net=axlDBFindByName('net "UART_RX")
  old=axlNetClassGet(net 'spacing t)
  when(old fprintf(f "CLASS_REASSIGN net=%L domain=%L old=%L new=%L\n" "UART_RX" 'spacing old->name "HI2L_UART_CAN_DIGITAL_S") unless(axlNetClassRemove(old net) error("Cannot remove prior class membership\n")))
  unless(axlNetClassAdd(nc net) error("Cannot bind2L netclass member\n"))
  net=axlDBFindByName('net "CAN_TXD")
  old=axlNetClassGet(net 'spacing t)
  when(old fprintf(f "CLASS_REASSIGN net=%L domain=%L old=%L new=%L\n" "CAN_TXD" 'spacing old->name "HI2L_UART_CAN_DIGITAL_S") unless(axlNetClassRemove(old net) error("Cannot remove prior class membership\n")))
  unless(axlNetClassAdd(nc net) error("Cannot bind2L netclass member\n"))
  net=axlDBFindByName('net "CAN_RXD")
  old=axlNetClassGet(net 'spacing t)
  when(old fprintf(f "CLASS_REASSIGN net=%L domain=%L old=%L new=%L\n" "CAN_RXD" 'spacing old->name "HI2L_UART_CAN_DIGITAL_S") unless(axlNetClassRemove(old net) error("Cannot remove prior class membership\n")))
  unless(axlNetClassAdd(nc net) error("Cannot bind2L netclass member\n"))
  nc=axlNetClassCreate("HI2L_UART_CAN_DIGITAL_E" 'electrical)
  unless(nc error("2L netclass create failed\n"))
  net=axlDBFindByName('net "PA9_UART_TX")
  old=axlNetClassGet(net 'electrical t)
  when(old fprintf(f "CLASS_REASSIGN net=%L domain=%L old=%L new=%L\n" "PA9_UART_TX" 'electrical old->name "HI2L_UART_CAN_DIGITAL_E") unless(axlNetClassRemove(old net) error("Cannot remove prior class membership\n")))
  unless(axlNetClassAdd(nc net) error("Cannot bind2L netclass member\n"))
  net=axlDBFindByName('net "PA10_UART_RX")
  old=axlNetClassGet(net 'electrical t)
  when(old fprintf(f "CLASS_REASSIGN net=%L domain=%L old=%L new=%L\n" "PA10_UART_RX" 'electrical old->name "HI2L_UART_CAN_DIGITAL_E") unless(axlNetClassRemove(old net) error("Cannot remove prior class membership\n")))
  unless(axlNetClassAdd(nc net) error("Cannot bind2L netclass member\n"))
  net=axlDBFindByName('net "UART_TX")
  old=axlNetClassGet(net 'electrical t)
  when(old fprintf(f "CLASS_REASSIGN net=%L domain=%L old=%L new=%L\n" "UART_TX" 'electrical old->name "HI2L_UART_CAN_DIGITAL_E") unless(axlNetClassRemove(old net) error("Cannot remove prior class membership\n")))
  unless(axlNetClassAdd(nc net) error("Cannot bind2L netclass member\n"))
  net=axlDBFindByName('net "UART_RX")
  old=axlNetClassGet(net 'electrical t)
  when(old fprintf(f "CLASS_REASSIGN net=%L domain=%L old=%L new=%L\n" "UART_RX" 'electrical old->name "HI2L_UART_CAN_DIGITAL_E") unless(axlNetClassRemove(old net) error("Cannot remove prior class membership\n")))
  unless(axlNetClassAdd(nc net) error("Cannot bind2L netclass member\n"))
  net=axlDBFindByName('net "CAN_TXD")
  old=axlNetClassGet(net 'electrical t)
  when(old fprintf(f "CLASS_REASSIGN net=%L domain=%L old=%L new=%L\n" "CAN_TXD" 'electrical old->name "HI2L_UART_CAN_DIGITAL_E") unless(axlNetClassRemove(old net) error("Cannot remove prior class membership\n")))
  unless(axlNetClassAdd(nc net) error("Cannot bind2L netclass member\n"))
  net=axlDBFindByName('net "CAN_RXD")
  old=axlNetClassGet(net 'electrical t)
  when(old fprintf(f "CLASS_REASSIGN net=%L domain=%L old=%L new=%L\n" "CAN_RXD" 'electrical old->name "HI2L_UART_CAN_DIGITAL_E") unless(axlNetClassRemove(old net) error("Cannot remove prior class membership\n")))
  unless(axlNetClassAdd(nc net) error("Cannot bind2L netclass member\n"))
  unless(axlCNSCreate('physical "HI2L_P_GPIO" nil) error("Cannot create2L physical CSet\n"))
  f29Must(axlCNSSetPhysical("HI2L_P_GPIO" nil 'width_min "0.2 MM") "2L specific physical value")
  f29Must(axlCNSSetPhysical("HI2L_P_GPIO" nil 'neckwidth_min "0.16 MM") "2L specific physical value")
  f29Must(axlCNSSetPhysical("HI2L_P_GPIO" nil 'necklength_max "1.0 MM") "2L specific physical value")
  f29Must(axlCNSSetPhysical("HI2L_P_GPIO" nil 'vias "L28_VIA030_C060") "Approved2L via")
  f29Must(axlCNSSetPhysical("HI2L_P_GPIO" "TOP" 'allow_etch t) "2L layer permission")
  f29Must(axlCNSSetPhysical("HI2L_P_GPIO" "BOTTOM" 'allow_etch t) "2L layer permission")
  unless(axlCNSCreate('spacing "HI2L_S_GPIO" nil) error("Cannot create2L spacing CSet\n"))
  f29Must(axlCNSSetSpacing("HI2L_S_GPIO" nil 'smdpin_line "0.2 MM") "2L explicit spacing value")
  f29Must(axlCNSSetSpacing("HI2L_S_GPIO" nil 'line_line "0.2 MM") "2L explicit spacing value")
  f29Must(axlCNSSetSpacing("HI2L_S_GPIO" nil 'via_line "0.2 MM") "2L explicit spacing value")
  f29Must(axlCNSSetSpacing("HI2L_S_GPIO" nil 'line_shape "0.2 MM") "2L explicit spacing value")
  f29Must(axlCNSSetSpacing("HI2L_S_GPIO" nil 'via_shape "0.2 MM") "2L explicit spacing value")
  f29Must(axlCNSSetSpacing("HI2L_S_GPIO" nil 'shape_shape "0.2 MM") "2L explicit spacing value")
  nc=axlNetClassCreate("HI2L_GPIO_P" 'physical)
  unless(nc error("2L netclass create failed\n"))
  axlDBAddProp(list(nc) list(list("PHYSICAL_CONSTRAINT_SET" "HI2L_P_GPIO")))
  net=axlDBFindByName('net "GPIO_PA1")
  old=axlNetClassGet(net 'physical t)
  when(old fprintf(f "CLASS_REASSIGN net=%L domain=%L old=%L new=%L\n" "GPIO_PA1" 'physical old->name "HI2L_GPIO_P") unless(axlNetClassRemove(old net) error("Cannot remove prior class membership\n")))
  unless(axlNetClassAdd(nc net) error("Cannot bind2L netclass member\n"))
  net=axlDBFindByName('net "GPIO_PA15")
  old=axlNetClassGet(net 'physical t)
  when(old fprintf(f "CLASS_REASSIGN net=%L domain=%L old=%L new=%L\n" "GPIO_PA15" 'physical old->name "HI2L_GPIO_P") unless(axlNetClassRemove(old net) error("Cannot remove prior class membership\n")))
  unless(axlNetClassAdd(nc net) error("Cannot bind2L netclass member\n"))
  net=axlDBFindByName('net "GPIO_PA2")
  old=axlNetClassGet(net 'physical t)
  when(old fprintf(f "CLASS_REASSIGN net=%L domain=%L old=%L new=%L\n" "GPIO_PA2" 'physical old->name "HI2L_GPIO_P") unless(axlNetClassRemove(old net) error("Cannot remove prior class membership\n")))
  unless(axlNetClassAdd(nc net) error("Cannot bind2L netclass member\n"))
  net=axlDBFindByName('net "GPIO_PA3")
  old=axlNetClassGet(net 'physical t)
  when(old fprintf(f "CLASS_REASSIGN net=%L domain=%L old=%L new=%L\n" "GPIO_PA3" 'physical old->name "HI2L_GPIO_P") unless(axlNetClassRemove(old net) error("Cannot remove prior class membership\n")))
  unless(axlNetClassAdd(nc net) error("Cannot bind2L netclass member\n"))
  net=axlDBFindByName('net "GPIO_PB1")
  old=axlNetClassGet(net 'physical t)
  when(old fprintf(f "CLASS_REASSIGN net=%L domain=%L old=%L new=%L\n" "GPIO_PB1" 'physical old->name "HI2L_GPIO_P") unless(axlNetClassRemove(old net) error("Cannot remove prior class membership\n")))
  unless(axlNetClassAdd(nc net) error("Cannot bind2L netclass member\n"))
  net=axlDBFindByName('net "GPIO_PB10")
  old=axlNetClassGet(net 'physical t)
  when(old fprintf(f "CLASS_REASSIGN net=%L domain=%L old=%L new=%L\n" "GPIO_PB10" 'physical old->name "HI2L_GPIO_P") unless(axlNetClassRemove(old net) error("Cannot remove prior class membership\n")))
  unless(axlNetClassAdd(nc net) error("Cannot bind2L netclass member\n"))
  net=axlDBFindByName('net "GPIO_PB11")
  old=axlNetClassGet(net 'physical t)
  when(old fprintf(f "CLASS_REASSIGN net=%L domain=%L old=%L new=%L\n" "GPIO_PB11" 'physical old->name "HI2L_GPIO_P") unless(axlNetClassRemove(old net) error("Cannot remove prior class membership\n")))
  unless(axlNetClassAdd(nc net) error("Cannot bind2L netclass member\n"))
  net=axlDBFindByName('net "GPIO_PB12")
  old=axlNetClassGet(net 'physical t)
  when(old fprintf(f "CLASS_REASSIGN net=%L domain=%L old=%L new=%L\n" "GPIO_PB12" 'physical old->name "HI2L_GPIO_P") unless(axlNetClassRemove(old net) error("Cannot remove prior class membership\n")))
  unless(axlNetClassAdd(nc net) error("Cannot bind2L netclass member\n"))
  net=axlDBFindByName('net "GPIO_PB13")
  old=axlNetClassGet(net 'physical t)
  when(old fprintf(f "CLASS_REASSIGN net=%L domain=%L old=%L new=%L\n" "GPIO_PB13" 'physical old->name "HI2L_GPIO_P") unless(axlNetClassRemove(old net) error("Cannot remove prior class membership\n")))
  unless(axlNetClassAdd(nc net) error("Cannot bind2L netclass member\n"))
  net=axlDBFindByName('net "GPIO_PB14")
  old=axlNetClassGet(net 'physical t)
  when(old fprintf(f "CLASS_REASSIGN net=%L domain=%L old=%L new=%L\n" "GPIO_PB14" 'physical old->name "HI2L_GPIO_P") unless(axlNetClassRemove(old net) error("Cannot remove prior class membership\n")))
  unless(axlNetClassAdd(nc net) error("Cannot bind2L netclass member\n"))
  net=axlDBFindByName('net "GPIO_PB15")
  old=axlNetClassGet(net 'physical t)
  when(old fprintf(f "CLASS_REASSIGN net=%L domain=%L old=%L new=%L\n" "GPIO_PB15" 'physical old->name "HI2L_GPIO_P") unless(axlNetClassRemove(old net) error("Cannot remove prior class membership\n")))
  unless(axlNetClassAdd(nc net) error("Cannot bind2L netclass member\n"))
  net=axlDBFindByName('net "GPIO_PB4")
  old=axlNetClassGet(net 'physical t)
  when(old fprintf(f "CLASS_REASSIGN net=%L domain=%L old=%L new=%L\n" "GPIO_PB4" 'physical old->name "HI2L_GPIO_P") unless(axlNetClassRemove(old net) error("Cannot remove prior class membership\n")))
  unless(axlNetClassAdd(nc net) error("Cannot bind2L netclass member\n"))
  net=axlDBFindByName('net "GPIO_PB5")
  old=axlNetClassGet(net 'physical t)
  when(old fprintf(f "CLASS_REASSIGN net=%L domain=%L old=%L new=%L\n" "GPIO_PB5" 'physical old->name "HI2L_GPIO_P") unless(axlNetClassRemove(old net) error("Cannot remove prior class membership\n")))
  unless(axlNetClassAdd(nc net) error("Cannot bind2L netclass member\n"))
  net=axlDBFindByName('net "GPIO_PB8")
  old=axlNetClassGet(net 'physical t)
  when(old fprintf(f "CLASS_REASSIGN net=%L domain=%L old=%L new=%L\n" "GPIO_PB8" 'physical old->name "HI2L_GPIO_P") unless(axlNetClassRemove(old net) error("Cannot remove prior class membership\n")))
  unless(axlNetClassAdd(nc net) error("Cannot bind2L netclass member\n"))
  net=axlDBFindByName('net "GPIO_PB9")
  old=axlNetClassGet(net 'physical t)
  when(old fprintf(f "CLASS_REASSIGN net=%L domain=%L old=%L new=%L\n" "GPIO_PB9" 'physical old->name "HI2L_GPIO_P") unless(axlNetClassRemove(old net) error("Cannot remove prior class membership\n")))
  unless(axlNetClassAdd(nc net) error("Cannot bind2L netclass member\n"))
  net=axlDBFindByName('net "GPIO_PC13")
  old=axlNetClassGet(net 'physical t)
  when(old fprintf(f "CLASS_REASSIGN net=%L domain=%L old=%L new=%L\n" "GPIO_PC13" 'physical old->name "HI2L_GPIO_P") unless(axlNetClassRemove(old net) error("Cannot remove prior class membership\n")))
  unless(axlNetClassAdd(nc net) error("Cannot bind2L netclass member\n"))
  net=axlDBFindByName('net "GPIO_PC14")
  old=axlNetClassGet(net 'physical t)
  when(old fprintf(f "CLASS_REASSIGN net=%L domain=%L old=%L new=%L\n" "GPIO_PC14" 'physical old->name "HI2L_GPIO_P") unless(axlNetClassRemove(old net) error("Cannot remove prior class membership\n")))
  unless(axlNetClassAdd(nc net) error("Cannot bind2L netclass member\n"))
  net=axlDBFindByName('net "GPIO_PC15")
  old=axlNetClassGet(net 'physical t)
  when(old fprintf(f "CLASS_REASSIGN net=%L domain=%L old=%L new=%L\n" "GPIO_PC15" 'physical old->name "HI2L_GPIO_P") unless(axlNetClassRemove(old net) error("Cannot remove prior class membership\n")))
  unless(axlNetClassAdd(nc net) error("Cannot bind2L netclass member\n"))
  nc=axlNetClassCreate("HI2L_GPIO_S" 'spacing)
  unless(nc error("2L netclass create failed\n"))
  axlDBAddProp(list(nc) list(list("SPACING_CONSTRAINT_SET" "HI2L_S_GPIO")))
  net=axlDBFindByName('net "GPIO_PA1")
  old=axlNetClassGet(net 'spacing t)
  when(old fprintf(f "CLASS_REASSIGN net=%L domain=%L old=%L new=%L\n" "GPIO_PA1" 'spacing old->name "HI2L_GPIO_S") unless(axlNetClassRemove(old net) error("Cannot remove prior class membership\n")))
  unless(axlNetClassAdd(nc net) error("Cannot bind2L netclass member\n"))
  net=axlDBFindByName('net "GPIO_PA15")
  old=axlNetClassGet(net 'spacing t)
  when(old fprintf(f "CLASS_REASSIGN net=%L domain=%L old=%L new=%L\n" "GPIO_PA15" 'spacing old->name "HI2L_GPIO_S") unless(axlNetClassRemove(old net) error("Cannot remove prior class membership\n")))
  unless(axlNetClassAdd(nc net) error("Cannot bind2L netclass member\n"))
  net=axlDBFindByName('net "GPIO_PA2")
  old=axlNetClassGet(net 'spacing t)
  when(old fprintf(f "CLASS_REASSIGN net=%L domain=%L old=%L new=%L\n" "GPIO_PA2" 'spacing old->name "HI2L_GPIO_S") unless(axlNetClassRemove(old net) error("Cannot remove prior class membership\n")))
  unless(axlNetClassAdd(nc net) error("Cannot bind2L netclass member\n"))
  net=axlDBFindByName('net "GPIO_PA3")
  old=axlNetClassGet(net 'spacing t)
  when(old fprintf(f "CLASS_REASSIGN net=%L domain=%L old=%L new=%L\n" "GPIO_PA3" 'spacing old->name "HI2L_GPIO_S") unless(axlNetClassRemove(old net) error("Cannot remove prior class membership\n")))
  unless(axlNetClassAdd(nc net) error("Cannot bind2L netclass member\n"))
  net=axlDBFindByName('net "GPIO_PB1")
  old=axlNetClassGet(net 'spacing t)
  when(old fprintf(f "CLASS_REASSIGN net=%L domain=%L old=%L new=%L\n" "GPIO_PB1" 'spacing old->name "HI2L_GPIO_S") unless(axlNetClassRemove(old net) error("Cannot remove prior class membership\n")))
  unless(axlNetClassAdd(nc net) error("Cannot bind2L netclass member\n"))
  net=axlDBFindByName('net "GPIO_PB10")
  old=axlNetClassGet(net 'spacing t)
  when(old fprintf(f "CLASS_REASSIGN net=%L domain=%L old=%L new=%L\n" "GPIO_PB10" 'spacing old->name "HI2L_GPIO_S") unless(axlNetClassRemove(old net) error("Cannot remove prior class membership\n")))
  unless(axlNetClassAdd(nc net) error("Cannot bind2L netclass member\n"))
  net=axlDBFindByName('net "GPIO_PB11")
  old=axlNetClassGet(net 'spacing t)
  when(old fprintf(f "CLASS_REASSIGN net=%L domain=%L old=%L new=%L\n" "GPIO_PB11" 'spacing old->name "HI2L_GPIO_S") unless(axlNetClassRemove(old net) error("Cannot remove prior class membership\n")))
  unless(axlNetClassAdd(nc net) error("Cannot bind2L netclass member\n"))
  net=axlDBFindByName('net "GPIO_PB12")
  old=axlNetClassGet(net 'spacing t)
  when(old fprintf(f "CLASS_REASSIGN net=%L domain=%L old=%L new=%L\n" "GPIO_PB12" 'spacing old->name "HI2L_GPIO_S") unless(axlNetClassRemove(old net) error("Cannot remove prior class membership\n")))
  unless(axlNetClassAdd(nc net) error("Cannot bind2L netclass member\n"))
  net=axlDBFindByName('net "GPIO_PB13")
  old=axlNetClassGet(net 'spacing t)
  when(old fprintf(f "CLASS_REASSIGN net=%L domain=%L old=%L new=%L\n" "GPIO_PB13" 'spacing old->name "HI2L_GPIO_S") unless(axlNetClassRemove(old net) error("Cannot remove prior class membership\n")))
  unless(axlNetClassAdd(nc net) error("Cannot bind2L netclass member\n"))
  net=axlDBFindByName('net "GPIO_PB14")
  old=axlNetClassGet(net 'spacing t)
  when(old fprintf(f "CLASS_REASSIGN net=%L domain=%L old=%L new=%L\n" "GPIO_PB14" 'spacing old->name "HI2L_GPIO_S") unless(axlNetClassRemove(old net) error("Cannot remove prior class membership\n")))
  unless(axlNetClassAdd(nc net) error("Cannot bind2L netclass member\n"))
  net=axlDBFindByName('net "GPIO_PB15")
  old=axlNetClassGet(net 'spacing t)
  when(old fprintf(f "CLASS_REASSIGN net=%L domain=%L old=%L new=%L\n" "GPIO_PB15" 'spacing old->name "HI2L_GPIO_S") unless(axlNetClassRemove(old net) error("Cannot remove prior class membership\n")))
  unless(axlNetClassAdd(nc net) error("Cannot bind2L netclass member\n"))
  net=axlDBFindByName('net "GPIO_PB4")
  old=axlNetClassGet(net 'spacing t)
  when(old fprintf(f "CLASS_REASSIGN net=%L domain=%L old=%L new=%L\n" "GPIO_PB4" 'spacing old->name "HI2L_GPIO_S") unless(axlNetClassRemove(old net) error("Cannot remove prior class membership\n")))
  unless(axlNetClassAdd(nc net) error("Cannot bind2L netclass member\n"))
  net=axlDBFindByName('net "GPIO_PB5")
  old=axlNetClassGet(net 'spacing t)
  when(old fprintf(f "CLASS_REASSIGN net=%L domain=%L old=%L new=%L\n" "GPIO_PB5" 'spacing old->name "HI2L_GPIO_S") unless(axlNetClassRemove(old net) error("Cannot remove prior class membership\n")))
  unless(axlNetClassAdd(nc net) error("Cannot bind2L netclass member\n"))
  net=axlDBFindByName('net "GPIO_PB8")
  old=axlNetClassGet(net 'spacing t)
  when(old fprintf(f "CLASS_REASSIGN net=%L domain=%L old=%L new=%L\n" "GPIO_PB8" 'spacing old->name "HI2L_GPIO_S") unless(axlNetClassRemove(old net) error("Cannot remove prior class membership\n")))
  unless(axlNetClassAdd(nc net) error("Cannot bind2L netclass member\n"))
  net=axlDBFindByName('net "GPIO_PB9")
  old=axlNetClassGet(net 'spacing t)
  when(old fprintf(f "CLASS_REASSIGN net=%L domain=%L old=%L new=%L\n" "GPIO_PB9" 'spacing old->name "HI2L_GPIO_S") unless(axlNetClassRemove(old net) error("Cannot remove prior class membership\n")))
  unless(axlNetClassAdd(nc net) error("Cannot bind2L netclass member\n"))
  net=axlDBFindByName('net "GPIO_PC13")
  old=axlNetClassGet(net 'spacing t)
  when(old fprintf(f "CLASS_REASSIGN net=%L domain=%L old=%L new=%L\n" "GPIO_PC13" 'spacing old->name "HI2L_GPIO_S") unless(axlNetClassRemove(old net) error("Cannot remove prior class membership\n")))
  unless(axlNetClassAdd(nc net) error("Cannot bind2L netclass member\n"))
  net=axlDBFindByName('net "GPIO_PC14")
  old=axlNetClassGet(net 'spacing t)
  when(old fprintf(f "CLASS_REASSIGN net=%L domain=%L old=%L new=%L\n" "GPIO_PC14" 'spacing old->name "HI2L_GPIO_S") unless(axlNetClassRemove(old net) error("Cannot remove prior class membership\n")))
  unless(axlNetClassAdd(nc net) error("Cannot bind2L netclass member\n"))
  net=axlDBFindByName('net "GPIO_PC15")
  old=axlNetClassGet(net 'spacing t)
  when(old fprintf(f "CLASS_REASSIGN net=%L domain=%L old=%L new=%L\n" "GPIO_PC15" 'spacing old->name "HI2L_GPIO_S") unless(axlNetClassRemove(old net) error("Cannot remove prior class membership\n")))
  unless(axlNetClassAdd(nc net) error("Cannot bind2L netclass member\n"))
  nc=axlNetClassCreate("HI2L_GPIO_E" 'electrical)
  unless(nc error("2L netclass create failed\n"))
  net=axlDBFindByName('net "GPIO_PA1")
  old=axlNetClassGet(net 'electrical t)
  when(old fprintf(f "CLASS_REASSIGN net=%L domain=%L old=%L new=%L\n" "GPIO_PA1" 'electrical old->name "HI2L_GPIO_E") unless(axlNetClassRemove(old net) error("Cannot remove prior class membership\n")))
  unless(axlNetClassAdd(nc net) error("Cannot bind2L netclass member\n"))
  net=axlDBFindByName('net "GPIO_PA15")
  old=axlNetClassGet(net 'electrical t)
  when(old fprintf(f "CLASS_REASSIGN net=%L domain=%L old=%L new=%L\n" "GPIO_PA15" 'electrical old->name "HI2L_GPIO_E") unless(axlNetClassRemove(old net) error("Cannot remove prior class membership\n")))
  unless(axlNetClassAdd(nc net) error("Cannot bind2L netclass member\n"))
  net=axlDBFindByName('net "GPIO_PA2")
  old=axlNetClassGet(net 'electrical t)
  when(old fprintf(f "CLASS_REASSIGN net=%L domain=%L old=%L new=%L\n" "GPIO_PA2" 'electrical old->name "HI2L_GPIO_E") unless(axlNetClassRemove(old net) error("Cannot remove prior class membership\n")))
  unless(axlNetClassAdd(nc net) error("Cannot bind2L netclass member\n"))
  net=axlDBFindByName('net "GPIO_PA3")
  old=axlNetClassGet(net 'electrical t)
  when(old fprintf(f "CLASS_REASSIGN net=%L domain=%L old=%L new=%L\n" "GPIO_PA3" 'electrical old->name "HI2L_GPIO_E") unless(axlNetClassRemove(old net) error("Cannot remove prior class membership\n")))
  unless(axlNetClassAdd(nc net) error("Cannot bind2L netclass member\n"))
  net=axlDBFindByName('net "GPIO_PB1")
  old=axlNetClassGet(net 'electrical t)
  when(old fprintf(f "CLASS_REASSIGN net=%L domain=%L old=%L new=%L\n" "GPIO_PB1" 'electrical old->name "HI2L_GPIO_E") unless(axlNetClassRemove(old net) error("Cannot remove prior class membership\n")))
  unless(axlNetClassAdd(nc net) error("Cannot bind2L netclass member\n"))
  net=axlDBFindByName('net "GPIO_PB10")
  old=axlNetClassGet(net 'electrical t)
  when(old fprintf(f "CLASS_REASSIGN net=%L domain=%L old=%L new=%L\n" "GPIO_PB10" 'electrical old->name "HI2L_GPIO_E") unless(axlNetClassRemove(old net) error("Cannot remove prior class membership\n")))
  unless(axlNetClassAdd(nc net) error("Cannot bind2L netclass member\n"))
  net=axlDBFindByName('net "GPIO_PB11")
  old=axlNetClassGet(net 'electrical t)
  when(old fprintf(f "CLASS_REASSIGN net=%L domain=%L old=%L new=%L\n" "GPIO_PB11" 'electrical old->name "HI2L_GPIO_E") unless(axlNetClassRemove(old net) error("Cannot remove prior class membership\n")))
  unless(axlNetClassAdd(nc net) error("Cannot bind2L netclass member\n"))
  net=axlDBFindByName('net "GPIO_PB12")
  old=axlNetClassGet(net 'electrical t)
  when(old fprintf(f "CLASS_REASSIGN net=%L domain=%L old=%L new=%L\n" "GPIO_PB12" 'electrical old->name "HI2L_GPIO_E") unless(axlNetClassRemove(old net) error("Cannot remove prior class membership\n")))
  unless(axlNetClassAdd(nc net) error("Cannot bind2L netclass member\n"))
  net=axlDBFindByName('net "GPIO_PB13")
  old=axlNetClassGet(net 'electrical t)
  when(old fprintf(f "CLASS_REASSIGN net=%L domain=%L old=%L new=%L\n" "GPIO_PB13" 'electrical old->name "HI2L_GPIO_E") unless(axlNetClassRemove(old net) error("Cannot remove prior class membership\n")))
  unless(axlNetClassAdd(nc net) error("Cannot bind2L netclass member\n"))
  net=axlDBFindByName('net "GPIO_PB14")
  old=axlNetClassGet(net 'electrical t)
  when(old fprintf(f "CLASS_REASSIGN net=%L domain=%L old=%L new=%L\n" "GPIO_PB14" 'electrical old->name "HI2L_GPIO_E") unless(axlNetClassRemove(old net) error("Cannot remove prior class membership\n")))
  unless(axlNetClassAdd(nc net) error("Cannot bind2L netclass member\n"))
  net=axlDBFindByName('net "GPIO_PB15")
  old=axlNetClassGet(net 'electrical t)
  when(old fprintf(f "CLASS_REASSIGN net=%L domain=%L old=%L new=%L\n" "GPIO_PB15" 'electrical old->name "HI2L_GPIO_E") unless(axlNetClassRemove(old net) error("Cannot remove prior class membership\n")))
  unless(axlNetClassAdd(nc net) error("Cannot bind2L netclass member\n"))
  net=axlDBFindByName('net "GPIO_PB4")
  old=axlNetClassGet(net 'electrical t)
  when(old fprintf(f "CLASS_REASSIGN net=%L domain=%L old=%L new=%L\n" "GPIO_PB4" 'electrical old->name "HI2L_GPIO_E") unless(axlNetClassRemove(old net) error("Cannot remove prior class membership\n")))
  unless(axlNetClassAdd(nc net) error("Cannot bind2L netclass member\n"))
  net=axlDBFindByName('net "GPIO_PB5")
  old=axlNetClassGet(net 'electrical t)
  when(old fprintf(f "CLASS_REASSIGN net=%L domain=%L old=%L new=%L\n" "GPIO_PB5" 'electrical old->name "HI2L_GPIO_E") unless(axlNetClassRemove(old net) error("Cannot remove prior class membership\n")))
  unless(axlNetClassAdd(nc net) error("Cannot bind2L netclass member\n"))
  net=axlDBFindByName('net "GPIO_PB8")
  old=axlNetClassGet(net 'electrical t)
  when(old fprintf(f "CLASS_REASSIGN net=%L domain=%L old=%L new=%L\n" "GPIO_PB8" 'electrical old->name "HI2L_GPIO_E") unless(axlNetClassRemove(old net) error("Cannot remove prior class membership\n")))
  unless(axlNetClassAdd(nc net) error("Cannot bind2L netclass member\n"))
  net=axlDBFindByName('net "GPIO_PB9")
  old=axlNetClassGet(net 'electrical t)
  when(old fprintf(f "CLASS_REASSIGN net=%L domain=%L old=%L new=%L\n" "GPIO_PB9" 'electrical old->name "HI2L_GPIO_E") unless(axlNetClassRemove(old net) error("Cannot remove prior class membership\n")))
  unless(axlNetClassAdd(nc net) error("Cannot bind2L netclass member\n"))
  net=axlDBFindByName('net "GPIO_PC13")
  old=axlNetClassGet(net 'electrical t)
  when(old fprintf(f "CLASS_REASSIGN net=%L domain=%L old=%L new=%L\n" "GPIO_PC13" 'electrical old->name "HI2L_GPIO_E") unless(axlNetClassRemove(old net) error("Cannot remove prior class membership\n")))
  unless(axlNetClassAdd(nc net) error("Cannot bind2L netclass member\n"))
  net=axlDBFindByName('net "GPIO_PC14")
  old=axlNetClassGet(net 'electrical t)
  when(old fprintf(f "CLASS_REASSIGN net=%L domain=%L old=%L new=%L\n" "GPIO_PC14" 'electrical old->name "HI2L_GPIO_E") unless(axlNetClassRemove(old net) error("Cannot remove prior class membership\n")))
  unless(axlNetClassAdd(nc net) error("Cannot bind2L netclass member\n"))
  net=axlDBFindByName('net "GPIO_PC15")
  old=axlNetClassGet(net 'electrical t)
  when(old fprintf(f "CLASS_REASSIGN net=%L domain=%L old=%L new=%L\n" "GPIO_PC15" 'electrical old->name "HI2L_GPIO_E") unless(axlNetClassRemove(old net) error("Cannot remove prior class membership\n")))
  unless(axlNetClassAdd(nc net) error("Cannot bind2L netclass member\n"))
  f29Must(axlNetClassDelete("G31_POWER_P") "Delete old empty G31 physical class")
  f29Must(axlNetClassDelete("G31_GND_P") "Delete old empty G31 physical class")
  f29Must(axlCNSCreate('physical "HI2L_P_MCU_ESCAPE_POWER_LV" "HI2L_P_POWER_LV") "2L G31 copy template")
  f29Must(axlCNSSetPhysical("HI2L_P_MCU_ESCAPE_POWER_LV" nil 'necklength_max "1.4 MM") "MCU local native center neck")
  f29Must(axlCnsClassTableCreate("HI2L_POWER_LV_P" nil oldRegion 'physical "HI2L_P_MCU_ESCAPE_POWER_LV") "Rebind G31 region to new class")
  f29Must(axlCNSCreate('spacing "HI2L_S_MCU_ESCAPE_POWER_LV" "HI2L_S_POWER_LV") "2L G31 copy template")
  f29Must(axlCNSSetSpacing("HI2L_S_MCU_ESCAPE_POWER_LV" nil 'smdpin_line "0.20 MM") "MCU local escape spacing")
  f29Must(axlCNSSetSpacing("HI2L_S_MCU_ESCAPE_POWER_LV" nil 'line_line "0.20 MM") "MCU local escape spacing")
  f29Must(axlCnsClassTableCreate("HI2L_POWER_LV_S" nil oldRegion 'spacing "HI2L_S_MCU_ESCAPE_POWER_LV") "Rebind G31 region to new class")
  f29Must(axlCNSCreate('physical "HI2L_P_MCU_ESCAPE_GROUND" "HI2L_P_GROUND") "2L G31 copy template")
  f29Must(axlCNSSetPhysical("HI2L_P_MCU_ESCAPE_GROUND" nil 'necklength_max "1.4 MM") "MCU local native center neck")
  f29Must(axlCnsClassTableCreate("HI2L_GROUND_P" nil oldRegion 'physical "HI2L_P_MCU_ESCAPE_GROUND") "Rebind G31 region to new class")
  f29Must(axlCNSCreate('spacing "HI2L_S_MCU_ESCAPE_GROUND" "HI2L_S_GROUND") "2L G31 copy template")
  f29Must(axlCNSSetSpacing("HI2L_S_MCU_ESCAPE_GROUND" nil 'smdpin_line "0.20 MM") "MCU local escape spacing")
  f29Must(axlCNSSetSpacing("HI2L_S_MCU_ESCAPE_GROUND" nil 'line_line "0.20 MM") "MCU local escape spacing")
  f29Must(axlCnsClassTableCreate("HI2L_GROUND_S" nil oldRegion 'spacing "HI2L_S_MCU_ESCAPE_GROUND") "Rebind G31 region to new class")
  f29Must(axlCNSCreate('spacing "HI2L_S_CLASSCLASS_1" nil) "2L class-class CSet")
  f29Must(axlCNSSetSpacing("HI2L_S_CLASSCLASS_1" nil 'smdpin_line "1.0 MM") "2L class-class copper isolation")
  f29Must(axlCNSSetSpacing("HI2L_S_CLASSCLASS_1" nil 'line_line "1.0 MM") "2L class-class copper isolation")
  f29Must(axlCNSSetSpacing("HI2L_S_CLASSCLASS_1" nil 'via_line "1.0 MM") "2L class-class copper isolation")
  f29Must(axlCNSSetSpacing("HI2L_S_CLASSCLASS_1" nil 'line_shape "1.0 MM") "2L class-class copper isolation")
  f29Must(axlCNSSetSpacing("HI2L_S_CLASSCLASS_1" nil 'via_shape "1.0 MM") "2L class-class copper isolation")
  f29Must(axlCNSSetSpacing("HI2L_S_CLASSCLASS_1" nil 'shape_shape "1.0 MM") "2L class-class copper isolation")
  f29Must(axlCnsClassTableCreate("HI2L_SWITCH_S" "HI2L_USB_FS_S" nil 'spacing "HI2L_S_CLASSCLASS_1") "Spacing-domain class-class association")
  f29Must(axlCNSCreate('spacing "HI2L_S_CLASSCLASS_2" nil) "2L class-class CSet")
  f29Must(axlCNSSetSpacing("HI2L_S_CLASSCLASS_2" nil 'smdpin_line "1.0 MM") "2L class-class copper isolation")
  f29Must(axlCNSSetSpacing("HI2L_S_CLASSCLASS_2" nil 'line_line "1.0 MM") "2L class-class copper isolation")
  f29Must(axlCNSSetSpacing("HI2L_S_CLASSCLASS_2" nil 'via_line "1.0 MM") "2L class-class copper isolation")
  f29Must(axlCNSSetSpacing("HI2L_S_CLASSCLASS_2" nil 'line_shape "1.0 MM") "2L class-class copper isolation")
  f29Must(axlCNSSetSpacing("HI2L_S_CLASSCLASS_2" nil 'via_shape "1.0 MM") "2L class-class copper isolation")
  f29Must(axlCNSSetSpacing("HI2L_S_CLASSCLASS_2" nil 'shape_shape "1.0 MM") "2L class-class copper isolation")
  f29Must(axlCnsClassTableCreate("HI2L_SWITCH_S" "HI2L_OSCILLATOR_S" nil 'spacing "HI2L_S_CLASSCLASS_2") "Spacing-domain class-class association")
  f29Must(axlCNSCreate('spacing "HI2L_S_CLASSCLASS_3" nil) "2L class-class CSet")
  f29Must(axlCNSSetSpacing("HI2L_S_CLASSCLASS_3" nil 'smdpin_line "1.0 MM") "2L class-class copper isolation")
  f29Must(axlCNSSetSpacing("HI2L_S_CLASSCLASS_3" nil 'line_line "1.0 MM") "2L class-class copper isolation")
  f29Must(axlCNSSetSpacing("HI2L_S_CLASSCLASS_3" nil 'via_line "1.0 MM") "2L class-class copper isolation")
  f29Must(axlCNSSetSpacing("HI2L_S_CLASSCLASS_3" nil 'line_shape "1.0 MM") "2L class-class copper isolation")
  f29Must(axlCNSSetSpacing("HI2L_S_CLASSCLASS_3" nil 'via_shape "1.0 MM") "2L class-class copper isolation")
  f29Must(axlCNSSetSpacing("HI2L_S_CLASSCLASS_3" nil 'shape_shape "1.0 MM") "2L class-class copper isolation")
  f29Must(axlCnsClassTableCreate("HI2L_SWITCH_S" "HI2L_ADC_S" nil 'spacing "HI2L_S_CLASSCLASS_3") "Spacing-domain class-class association")
  f29Must(axlCNSCreate('spacing "HI2L_S_CLASSCLASS_4" nil) "2L class-class CSet")
  f29Must(axlCNSSetSpacing("HI2L_S_CLASSCLASS_4" nil 'smdpin_line "1.0 MM") "2L class-class copper isolation")
  f29Must(axlCNSSetSpacing("HI2L_S_CLASSCLASS_4" nil 'line_line "1.0 MM") "2L class-class copper isolation")
  f29Must(axlCNSSetSpacing("HI2L_S_CLASSCLASS_4" nil 'via_line "1.0 MM") "2L class-class copper isolation")
  f29Must(axlCNSSetSpacing("HI2L_S_CLASSCLASS_4" nil 'line_shape "1.0 MM") "2L class-class copper isolation")
  f29Must(axlCNSSetSpacing("HI2L_S_CLASSCLASS_4" nil 'via_shape "1.0 MM") "2L class-class copper isolation")
  f29Must(axlCNSSetSpacing("HI2L_S_CLASSCLASS_4" nil 'shape_shape "1.0 MM") "2L class-class copper isolation")
  f29Must(axlCnsClassTableCreate("HI2L_SWITCH_S" "HI2L_FEEDBACK_S" nil 'spacing "HI2L_S_CLASSCLASS_4") "Spacing-domain class-class association")
  f29Must(axlCNSCreate('spacing "HI2L_S_CLASSCLASS_5" nil) "2L class-class CSet")
  f29Must(axlCNSSetSpacing("HI2L_S_CLASSCLASS_5" nil 'smdpin_line "0.5 MM") "2L class-class copper isolation")
  f29Must(axlCNSSetSpacing("HI2L_S_CLASSCLASS_5" nil 'line_line "0.5 MM") "2L class-class copper isolation")
  f29Must(axlCNSSetSpacing("HI2L_S_CLASSCLASS_5" nil 'via_line "0.5 MM") "2L class-class copper isolation")
  f29Must(axlCNSSetSpacing("HI2L_S_CLASSCLASS_5" nil 'line_shape "0.5 MM") "2L class-class copper isolation")
  f29Must(axlCNSSetSpacing("HI2L_S_CLASSCLASS_5" nil 'via_shape "0.5 MM") "2L class-class copper isolation")
  f29Must(axlCNSSetSpacing("HI2L_S_CLASSCLASS_5" nil 'shape_shape "0.5 MM") "2L class-class copper isolation")
  f29Must(axlCnsClassTableCreate("HI2L_USB_FS_S" "HI2L_GPIO_S" nil 'spacing "HI2L_S_CLASSCLASS_5") "Spacing-domain class-class association")
  f29Must(axlCNSCreate('spacing "HI2L_S_CLASSCLASS_6" nil) "2L class-class CSet")
  f29Must(axlCNSSetSpacing("HI2L_S_CLASSCLASS_6" nil 'smdpin_line "0.5 MM") "2L class-class copper isolation")
  f29Must(axlCNSSetSpacing("HI2L_S_CLASSCLASS_6" nil 'line_line "0.5 MM") "2L class-class copper isolation")
  f29Must(axlCNSSetSpacing("HI2L_S_CLASSCLASS_6" nil 'via_line "0.5 MM") "2L class-class copper isolation")
  f29Must(axlCNSSetSpacing("HI2L_S_CLASSCLASS_6" nil 'line_shape "0.5 MM") "2L class-class copper isolation")
  f29Must(axlCNSSetSpacing("HI2L_S_CLASSCLASS_6" nil 'via_shape "0.5 MM") "2L class-class copper isolation")
  f29Must(axlCNSSetSpacing("HI2L_S_CLASSCLASS_6" nil 'shape_shape "0.5 MM") "2L class-class copper isolation")
  f29Must(axlCnsClassTableCreate("HI2L_USB_FS_S" "HI2L_RESET_BOOT_SWD_S" nil 'spacing "HI2L_S_CLASSCLASS_6") "Spacing-domain class-class association")
  f29Must(axlCNSCreate('spacing "HI2L_S_CLASSCLASS_7" nil) "2L class-class CSet")
  f29Must(axlCNSSetSpacing("HI2L_S_CLASSCLASS_7" nil 'smdpin_line "0.5 MM") "2L class-class copper isolation")
  f29Must(axlCNSSetSpacing("HI2L_S_CLASSCLASS_7" nil 'line_line "0.5 MM") "2L class-class copper isolation")
  f29Must(axlCNSSetSpacing("HI2L_S_CLASSCLASS_7" nil 'via_line "0.5 MM") "2L class-class copper isolation")
  f29Must(axlCNSSetSpacing("HI2L_S_CLASSCLASS_7" nil 'line_shape "0.5 MM") "2L class-class copper isolation")
  f29Must(axlCNSSetSpacing("HI2L_S_CLASSCLASS_7" nil 'via_shape "0.5 MM") "2L class-class copper isolation")
  f29Must(axlCNSSetSpacing("HI2L_S_CLASSCLASS_7" nil 'shape_shape "0.5 MM") "2L class-class copper isolation")
  f29Must(axlCnsClassTableCreate("HI2L_USB_FS_S" "HI2L_SPI_S" nil 'spacing "HI2L_S_CLASSCLASS_7") "Spacing-domain class-class association")
  f29Must(axlCNSCreate('spacing "HI2L_S_CLASSCLASS_8" nil) "2L class-class CSet")
  f29Must(axlCNSSetSpacing("HI2L_S_CLASSCLASS_8" nil 'smdpin_line "0.5 MM") "2L class-class copper isolation")
  f29Must(axlCNSSetSpacing("HI2L_S_CLASSCLASS_8" nil 'line_line "0.5 MM") "2L class-class copper isolation")
  f29Must(axlCNSSetSpacing("HI2L_S_CLASSCLASS_8" nil 'via_line "0.5 MM") "2L class-class copper isolation")
  f29Must(axlCNSSetSpacing("HI2L_S_CLASSCLASS_8" nil 'line_shape "0.5 MM") "2L class-class copper isolation")
  f29Must(axlCNSSetSpacing("HI2L_S_CLASSCLASS_8" nil 'via_shape "0.5 MM") "2L class-class copper isolation")
  f29Must(axlCNSSetSpacing("HI2L_S_CLASSCLASS_8" nil 'shape_shape "0.5 MM") "2L class-class copper isolation")
  f29Must(axlCnsClassTableCreate("HI2L_USB_FS_S" "HI2L_UART_CAN_DIGITAL_S" nil 'spacing "HI2L_S_CLASSCLASS_8") "Spacing-domain class-class association")
  f29Must(axlCNSCreate('spacing "HI2L_S_CLASSCLASS_9" nil) "2L class-class CSet")
  f29Must(axlCNSSetSpacing("HI2L_S_CLASSCLASS_9" nil 'smdpin_line "0.5 MM") "2L class-class copper isolation")
  f29Must(axlCNSSetSpacing("HI2L_S_CLASSCLASS_9" nil 'line_line "0.5 MM") "2L class-class copper isolation")
  f29Must(axlCNSSetSpacing("HI2L_S_CLASSCLASS_9" nil 'via_line "0.5 MM") "2L class-class copper isolation")
  f29Must(axlCNSSetSpacing("HI2L_S_CLASSCLASS_9" nil 'line_shape "0.5 MM") "2L class-class copper isolation")
  f29Must(axlCNSSetSpacing("HI2L_S_CLASSCLASS_9" nil 'via_shape "0.5 MM") "2L class-class copper isolation")
  f29Must(axlCNSSetSpacing("HI2L_S_CLASSCLASS_9" nil 'shape_shape "0.5 MM") "2L class-class copper isolation")
  f29Must(axlCnsClassTableCreate("HI2L_USB_FS_S" "HI2L_I2C_S" nil 'spacing "HI2L_S_CLASSCLASS_9") "Spacing-domain class-class association")
  f29Must(axlCNSCreate('spacing "HI2L_S_CLASSCLASS_10" nil) "2L class-class CSet")
  f29Must(axlCNSSetSpacing("HI2L_S_CLASSCLASS_10" nil 'smdpin_line "0.5 MM") "2L class-class copper isolation")
  f29Must(axlCNSSetSpacing("HI2L_S_CLASSCLASS_10" nil 'line_line "0.5 MM") "2L class-class copper isolation")
  f29Must(axlCNSSetSpacing("HI2L_S_CLASSCLASS_10" nil 'via_line "0.5 MM") "2L class-class copper isolation")
  f29Must(axlCNSSetSpacing("HI2L_S_CLASSCLASS_10" nil 'line_shape "0.5 MM") "2L class-class copper isolation")
  f29Must(axlCNSSetSpacing("HI2L_S_CLASSCLASS_10" nil 'via_shape "0.5 MM") "2L class-class copper isolation")
  f29Must(axlCNSSetSpacing("HI2L_S_CLASSCLASS_10" nil 'shape_shape "0.5 MM") "2L class-class copper isolation")
  f29Must(axlCnsClassTableCreate("HI2L_USB_FS_S" "HI2L_USB_AUX_S" nil 'spacing "HI2L_S_CLASSCLASS_10") "Spacing-domain class-class association")
  f29Must(axlCNSEcsetCreate("HI2L_E_USB_BUDGET") "2L USB explicit ECSet")
  f29Must(axlCNSEcsetValueSet("HI2L_E_USB_BUDGET" 'Maximum_Via_Count 2) "2L USB max via budget")
  f29Must(axlCNSEcsetValueSet("HI2L_E_USB_BUDGET" 'Differential_Pair_Phase_Tolerance "1 MM") "2L USB phase teaching budget")
  f29Must(axlCNSEcsetValueSet("HI2L_E_USB_BUDGET" 'Differential_Pair_Max_Uncoupled_Length "6 MM") "2L USB uncoupled teaching budget")
  pair=f29Must(axlDiffPair("DP_USB_CONNECTOR" "USB_DP" "USB_DM") "2L native diff pair object")
  axlDBAddProp(list(pair) list(list("ELECTRICAL_CONSTRAINT_SET" "HI2L_E_USB_BUDGET")))
  pair=f29Must(axlDiffPair("DP_USB_MCU_SIDE" "PA12_SHARED" "PA11_SHARED") "2L native diff pair object")
  axlDBAddProp(list(pair) list(list("ELECTRICAL_CONSTRAINT_SET" "HI2L_E_USB_BUDGET")))
  pair=f29Must(axlDiffPair("DP_CAN_BUS" "CAN_H" "CAN_L") "2L native diff pair object")
  nc=car(setof(c axlDBGetDesign()->netclass equal(c->name "HI2L_USB_FS_E")))
  axlDBAddProp(list(nc) list(list("ELECTRICAL_CONSTRAINT_SET" "HI2L_E_USB_BUDGET")))
  f29Must(axlCNSSetPhysical("HI2L_P_USB_FS" nil 'dp_primary_gap "0.16 MM") "2L provisional differential geometry, not90ohm")
  f29Must(axlCNSSetPhysical("HI2L_P_USB_FS" nil 'dp_neck_gap "0.16 MM") "2L provisional differential geometry, not90ohm")
  f29Must(axlCNSSetPhysical("HI2L_P_USB_FS" nil 'dp_min_gap "0.16 MM") "2L provisional differential geometry, not90ohm")
  axlCNSPhysicalModeSet('width_min 'on)
  axlCNSPhysicalModeSet('vias 'on)
  axlCNSPhysicalModeSet('allow_etch 'on)
  axlCNSSpacingModeSet('all 'on)
  axlCNSEcsetModeSet('Maximum_Via_Count 'on)
  axlCNSEcsetModeSet('Differential_Pair_Primary_Gap 'on)
  axlCNSMapUpdate()
  foreach(net axlDBGetDesign()->nets foreach(domain list('physical 'spacing 'electrical) unless(axlNetClassGet(net domain t) error("2L net fell back without class\n"))))
  fprintf(f "HI2L_ALL69_CLASSIFIED_IN3_DOMAINS\n")
  hiFinalize(f out board lib nil)
  hiExtraRead(out)
  t))
