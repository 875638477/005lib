procedure(hiReadbackProofs()
 let((f)
  f=outfile("D:/001DIY/005lib/01AIEDA/learning/examples/lessonHI_38_50_20261021/logs/reopen_usb_esd_4L_b008/hi_reopen_endpoint_proofs.txt")
  hiRegistry=nil
  hiNodeDefinitions=list(list("USB_DP_MIRROR_A" "USB_DP" "TOP" list(39.75 5.8) "via") list("USB_DP_MIRROR_B" "USB_DP" "TOP" list(40.75 5.8) "via") list("USB_DP_A6_TO_MIRROR" "USB_DP" "TOP" list(39.75 7.355) "point") list("USB_DP_B6_TO_MIRROR" "USB_DP" "TOP" list(40.75 7.355) "point") list("USB_DP_MIRROR_BOTTOM" "USB_DP" "BOTTOM" list(39.75 5.8) "point") list("USB_DM_A7_MERGE" "USB_DM" "TOP" list(40.25 7.355) "point") list("USB_DP_ENTRY" "USB_DP" "TOP" list(40.75 7.355) "point") list("USB_DM_ENTRY" "USB_DM" "TOP" list(39.25 7.355) "point") list("USB_SHARED_DP" "PA12_SHARED" "TOP" list(41.1 18.3984) "point") list("USB_DNP_STUB_DP" "PA12_SHARED" "TOP" list(41.1 18.3984) "point") list("USB_DNP_STUB_DM" "PA11_SHARED" "TOP" list(39.4 18.3984) "point") list("USB_RETURN_LEFT" "GND" "TOP" list(38.15 5.8) "via") list("USB_RETURN_RIGHT" "GND" "TOP" list(41.7 5.8) "via") list("USB_U4_DP_FLOW" "USB_DP" "TOP" list(41.2 10.1) "point") list("USB_U4_DM_FLOW" "USB_DM" "TOP" list(39.3 10.1) "point") list("USB4L_PROTECTED_DP" "USB_DP" "TOP" list(41.2 12.7) "point") list("USB4L_PROTECTED_DM" "USB_DM" "TOP" list(39.3 12.7) "point") list("USB_PULLUP_BRANCH" "USB_DP" "TOP" list(40.455 14.6) "point") list("USB_SHARED_DM" "PA11_SHARED" "TOP" list(39.4 18.3984) "point") list("ESD_U4_RETURN" "GND" "TOP" list(40.25 12.7) "point") list("V_HI_ESD_A" "GND" "TOP" list(40.0 11.4) "via") list("ESD_U4_SECOND_VIA" "GND" "TOP" list(40.25 11.8) "point") list("V_HI_ESD_B" "GND" "TOP" list(40.5 11.6) "via") list("ESD_C10_RETURN" "GND" "TOP" list(42.7 10.7764) "point") list("V_HI_C10_A" "GND" "TOP" list(43.8 10.7764) "via") list("V_HI_C10_B" "GND" "TOP" list(43.8 11.5764) "via") list("ESD_VBUS_U4_ESCAPE" "USB_VBUS" "TOP" list(40.25 10.1) "point") list("V_HI_ESD_VBUS_LEFT" "USB_VBUS" "TOP" list(40.25 9.3) "via") list("ESD_VBUS_BOTTOM_BRIDGE" "USB_VBUS" "BOTTOM" list(40.25 9.3) "point") list("V_HI_C10_VBUS" "USB_VBUS" "TOP" list(43.8 9.2016) "via") list("ESD_VBUS_C10" "USB_VBUS" "TOP" list(43.8 9.2016) "point") list("USB_DP_TRUNK_NODE" "USB_DP" "TOP" list(40.455 14.6) "point"))
  hiBindExistingVia(f "USB_DP_MIRROR_A" "USB_DP" list(39.75 5.8) "L28_VIA030_C060")
  hiBindExistingVia(f "USB_DP_MIRROR_B" "USB_DP" list(40.75 5.8) "L28_VIA030_C060")
  hiBindExistingVia(f "USB_RETURN_LEFT" "GND" list(38.15 5.8) "L28_VIA030_C060")
  hiBindExistingVia(f "USB_RETURN_RIGHT" "GND" list(41.7 5.8) "L28_VIA030_C060")
  hiBindExistingVia(f "V_HI_ESD_A" "GND" list(40.0 11.4) "L28_VIA030_C060")
  hiBindExistingVia(f "V_HI_ESD_B" "GND" list(40.5 11.6) "L28_VIA030_C060")
  hiBindExistingVia(f "V_HI_C10_A" "GND" list(43.8 10.7764) "L28_VIA030_C060")
  hiBindExistingVia(f "V_HI_C10_B" "GND" list(43.8 11.5764) "L28_VIA030_C060")
  hiBindExistingVia(f "V_HI_ESD_VBUS_LEFT" "USB_VBUS" list(40.25 9.3) "L28_VIA030_C060")
  hiBindExistingVia(f "V_HI_C10_VBUS" "USB_VBUS" list(43.8 9.2016) "L28_VIA030_C060")
  hiProof(f "J2.A6" "USB_DP_MIRROR_A" t)
  hiProof(f "J2.B6" "USB_DP_MIRROR_B" t)
  hiProof(f "USB_DP_MIRROR_A" "USB_DP_MIRROR_B" t)
  hiProof(f "J2.A7" "J2.B7" t)
  hiProof(f "J2.B6" "U4.6" t)
  hiProof(f "J2.B7" "U4.4" t)
  hiProof(f "R5.1" "U1.33" t)
  hiProof(f "R5.1" "R12.1" t)
  hiProof(f "R6.1" "R13.1" t)
  hiProof(f "U4.6" "U4.1" t)
  hiProof(f "U4.4" "U4.3" t)
  hiProof(f "U4.1" "R5.2" t)
  hiProof(f "U4.3" "R6.2" t)
  hiProof(f "USB_DP_TRUNK_NODE" "R11.2" t)
  hiProof(f "R6.1" "U1.32" t)
  hiProof(f "U4.2" "V_HI_ESD_A" t)
  hiProof(f "ESD_U4_RETURN" "V_HI_ESD_B" t)
  hiProof(f "C10.2" "V_HI_C10_B" t)
  hiProof(f "U4.5" "V_HI_ESD_VBUS_LEFT" t)
  hiProof(f "V_HI_ESD_VBUS_LEFT" "V_HI_C10_VBUS" t)
  hiProof(f "V_HI_C10_VBUS" "C10.1" t)
  hiProof(f "J2.A6" "U4.6" t)
  hiProof(f "J2.B6" "U4.6" t)
  hiProof(f "J2.A7" "U4.4" t)
  hiProof(f "J2.B7" "U4.4" t)
  hiProof(f "U4.1" "R5.2" t)
  hiProof(f "U4.3" "R6.2" t)
  hiProof(f "R11.2" "R5.2" t)
  hiProof(f "R5.1" "U1.33" t)
  hiProof(f "R6.1" "U1.32" t)
  hiProof(f "U4.2" "U1.47" t)
  hiProof(f "C10.2" "U1.47" t)
  hiHSEIsolationChallenge("D:/001DIY/005lib/01AIEDA/learning/examples/lessonHI_38_50_20261021/logs/reopen_usb_esd_4L_b008" list(45.45 28.85) "L2" list(list(42.2 39.8) list(44.2 39.8) list(47.8 33.5)))
  fprintf(f "HI_REOPEN_ALL_ENDPOINTS_COMPLETE\n") close(f) t))
