procedure(hiCumulativePhysicalRead(out)
 let((f)
 f=outfile(strcat(out "/hi_cumulative_physical_pin_proofs.txt"))
 hiRegistry=nil hiNodeDefinitions=nil
 hiPhysicalTerminalContract(f list(list("J2" "SH4" "GND" "L10_USB4105_SLOT060X140") list("J2" "SH3" "GND" "L10_USB4105_SLOT060X140") list("J2" "SH2" "GND" "L10_USB4105_SLOT060X170") list("J2" "SH1" "GND" "L10_USB4105_SLOT060X170") list("J2" "B1_A12" "GND" "L10_USB4105_SMD060X115") list("J2" "B4_A9" "USB_VBUS" "L10_USB4105_SMD060X115") list("J2" "B5" "USB_CC2" "L10_USB4105_SMD030X115") list("J2" "A8" nil "L10_USB4105_SMD030X115") list("J2" "B6" "USB_DP" "L10_USB4105_SMD030X115") list("J2" "A7" "USB_DM" "L10_USB4105_SMD030X115") list("J2" "A6" "USB_DP" "L10_USB4105_SMD030X115") list("J2" "B7" "USB_DM" "L10_USB4105_SMD030X115") list("J2" "A5" "USB_CC1" "L10_USB4105_SMD030X115") list("J2" "B8" nil "L10_USB4105_SMD030X115") list("J2" "A4_B9" "USB_VBUS" "L10_USB4105_SMD060X115") list("J2" "A1_B12" "GND" "L10_USB4105_SMD060X115") list("J3" "3" "GND" "VIA_1D0_1D54") list("J3" "2" "CAN_L" "VIA_1D0_1D54") list("J3" "1" "CAN_H" "VIA_1D0_1D54S") list("J4" "4" "GND" "VIA_1D0_1D54") list("J4" "3" "UART_RX" "VIA_1D0_1D54") list("J4" "2" "UART_TX" "VIA_1D0_1D54") list("J4" "1" "V3V3" "VIA_1D0_1D54S") list("J5" "4" "GND" "VIA_1D0_1D54") list("J5" "3" "I2C_SDA" "VIA_1D0_1D54") list("J5" "2" "I2C_SCL" "VIA_1D0_1D54") list("J5" "1" "V3V3" "VIA_1D0_1D54S") list("J6" "6" "GND" "VIAS_30_CIRCLE") list("J6" "5" "SPI_NSS" "VIAS_30_CIRCLE") list("J6" "4" "SPI_MISO" "VIAS_30_CIRCLE") list("J6" "3" "SPI_MOSI" "VIAS_30_CIRCLE") list("J6" "2" "SPI_SCK" "VIAS_30_CIRCLE") list("J6" "1" "V3V3" "VIAS_30_SQUARE") list("J9" "6" "SWO" "VIAS_30_CIRCLE") list("J9" "5" "NRST" "VIAS_30_CIRCLE") list("J9" "4" "SWCLK" "VIAS_30_CIRCLE") list("J9" "3" "SWDIO" "VIAS_30_CIRCLE") list("J9" "2" "GND" "VIAS_30_CIRCLE") list("J9" "1" "V3V3" "VIAS_30_SQUARE") list("J11" "8" "GPIO_PA3" "VIA_1D0_1D54") list("J11" "7" "GPIO_PA2" "VIA_1D0_1D54") list("J11" "6" "GPIO_PA1" "VIA_1D0_1D54") list("J11" "5" "GPIO_PC15" "VIA_1D0_1D54") list("J11" "4" "GPIO_PC14" "VIA_1D0_1D54") list("J11" "3" "GPIO_PC13" "VIA_1D0_1D54") list("J11" "2" "GND" "VIA_1D0_1D54") list("J11" "1" "V3V3" "VIA_1D0_1D54S") list("J12" "8" "GPIO_PB14" "VIA_1D0_1D54") list("J12" "7" "GPIO_PB13" "VIA_1D0_1D54") list("J12" "6" "GPIO_PB12" "VIA_1D0_1D54") list("J12" "5" "GPIO_PB11" "VIA_1D0_1D54") list("J12" "4" "GPIO_PB10" "VIA_1D0_1D54") list("J12" "3" "GPIO_PB1" "VIA_1D0_1D54") list("J12" "2" "GND" "VIA_1D0_1D54") list("J12" "1" "V3V3" "VIA_1D0_1D54S") list("J13" "8" "GPIO_PB9" "VIA_1D0_1D54") list("J13" "7" "GPIO_PB8" "VIA_1D0_1D54") list("J13" "6" "GPIO_PB5" "VIA_1D0_1D54") list("J13" "5" "GPIO_PB4" "VIA_1D0_1D54") list("J13" "4" "GPIO_PA15" "VIA_1D0_1D54") list("J13" "3" "GPIO_PB15" "VIA_1D0_1D54") list("J13" "2" "GND" "VIA_1D0_1D54") list("J13" "1" "V3V3" "VIA_1D0_1D54S") list("R23" "1" "PA4_SPI_NSS" "SMD_37X32RET") list("R23" "2" "SPI_NSS" "SMD_37X32RET") list("R21" "1" "PA5_SPI_SCK" "SMD_37X32RET") list("R21" "2" "SPI_SCK" "SMD_37X32RET") list("R24" "1" "PA6_SPI_MISO" "SMD_37X32RET") list("R24" "2" "SPI_MISO" "SMD_37X32RET") list("R22" "1" "PA7_SPI_MOSI" "SMD_37X32RET") list("R22" "2" "SPI_MOSI" "SMD_37X32RET") list("R25" "1" "V3V3" "SMD_37X32RET") list("R25" "2" "PA4_SPI_NSS" "SMD_37X32RET") list("R19" "1" "V3V3" "SMD_37X32RET") list("R19" "2" "I2C_SCL" "SMD_37X32RET") list("R20" "1" "V3V3" "SMD_37X32RET") list("R20" "2" "I2C_SDA" "SMD_37X32RET") list("C13" "1" "V3V3" "SMD_37X32RET") list("C13" "2" "GND" "SMD_37X32RET") list("C14" "1" "V3V3" "SMD_37X32RET") list("C14" "2" "GND" "SMD_37X32RET") list("C15" "1" "V3V3" "SMD_37X32RET") list("C15" "2" "GND" "SMD_37X32RET") list("C17" "1" "V3V3" "SMD_37X32RET") list("C17" "2" "GND" "SMD_37X32RET") list("C18" "1" "VDDA" "SMD_37X32RET") list("C18" "2" "GND" "SMD_37X32RET") list("C19" "1" "VDDA" "SMD_37X32RET") list("C19" "2" "GND" "SMD_37X32RET") list("C21" "1" "NRST" "SMD_37X32RET") list("C21" "2" "GND" "SMD_37X32RET") list("C22" "1" "OSC_IN" "SMD_37X32RET") list("C22" "2" "GND" "SMD_37X32RET") list("C23" "1" "XTAL_OUT" "SMD_37X32RET") list("C23" "2" "GND" "SMD_37X32RET") list("C24" "1" "ADC0" "SMD_37X32RET") list("C24" "2" "GND" "SMD_37X32RET") list("R26" "1" "V3V3" "SMD_37X32RET") list("R26" "2" "VDDA" "SMD_37X32RET") list("R27" "1" "V3V3" "SMD_37X32RET") list("R27" "2" "NRST" "SMD_37X32RET") list("R28" "1" "BOOT0" "SMD_37X32RET") list("R28" "2" "GND" "SMD_37X32RET") list("R29" "1" "BOOT1" "SMD_37X32RET") list("R29" "2" "GND" "SMD_37X32RET") list("R30" "1" "V3V3" "SMD_37X32RET") list("R30" "2" "BOOT_SERVICE" "SMD_37X32RET") list("R31" "1" "OSC_OUT" "SMD_37X32RET") list("R31" "2" "XTAL_OUT" "SMD_37X32RET") list("R32" "1" "ADC_IN" "SMD_37X32RET") list("R32" "2" "ADC0" "SMD_37X32RET") list("F1" "1" "VIN_RAW" "SMD_37X32RET") list("F1" "2" "VIN_FUSED" "SMD_37X32RET") list("C3" "1" "VIN_PROT" "SMD_37X32RET") list("C3" "2" "GND" "SMD_37X32RET") list("C4" "1" "BUCK_BOOT" "SMD_37X32RET") list("C4" "2" "BUCK_SW" "SMD_37X32RET") list("R1" "1" "V5" "SMD_37X32RET") list("R1" "2" "BUCK_FB" "SMD_37X32RET") list("R2" "1" "BUCK_FB" "SMD_37X32RET") list("R2" "2" "GND" "SMD_37X32RET") list("C7" "1" "V5" "SMD_37X32RET") list("C7" "2" "BUCK_FB" "SMD_37X32RET") list("C10" "1" "USB_VBUS" "SMD_37X32RET") list("C10" "2" "GND" "SMD_37X32RET") list("R3" "1" "USB_CC1" "SMD_37X32RET") list("R3" "2" "GND" "SMD_37X32RET") list("R4" "1" "USB_CC2" "SMD_37X32RET") list("R4" "2" "GND" "SMD_37X32RET") list("R5" "1" "PA12_SHARED" "SMD_37X32RET") list("R5" "2" "USB_DP" "SMD_37X32RET") list("R6" "1" "PA11_SHARED" "SMD_37X32RET") list("R6" "2" "USB_DM" "SMD_37X32RET") list("R7" "1" "USB_VBUS" "SMD_37X32RET") list("R7" "2" "VBUS_GATE" "SMD_37X32RET") list("R8" "1" "VBUS_GATE" "SMD_37X32RET") list("R8" "2" "GND" "SMD_37X32RET") list("R9" "1" "V3V3" "SMD_37X32RET") list("R9" "2" "VBUS_PRESENT_N" "SMD_37X32RET") list("R10" "1" "V3V3" "SMD_37X32RET") list("R10" "2" "USB_ATTACH_N" "SMD_37X32RET") list("R11" "1" "USB_PULLUP_SRC" "SMD_37X32RET") list("R11" "2" "USB_DP" "SMD_37X32RET") list("R12" "1" "PA12_SHARED" "SMD_37X32RET") list("R12" "2" "CAN_TXD" "SMD_37X32RET") list("R13" "1" "PA11_SHARED" "SMD_37X32RET") list("R13" "2" "CAN_RXD" "SMD_37X32RET") list("C11" "1" "V3V3" "SMD_37X32RET") list("C11" "2" "GND" "SMD_37X32RET") list("C12" "1" "V3V3" "SMD_37X32RET") list("C12" "2" "GND" "SMD_37X32RET") list("R14" "1" "V3V3" "SMD_37X32RET") list("R14" "2" "CAN_TXD" "SMD_37X32RET") list("R16" "1" "PA9_UART_TX" "SMD_37X32RET") list("R16" "2" "UART_TX" "SMD_37X32RET") list("R17" "1" "PA10_UART_RX" "SMD_37X32RET") list("R17" "2" "UART_RX" "SMD_37X32RET") list("R18" "1" "UART_RX" "SMD_37X32RET") list("R18" "2" "V3V3" "SMD_37X32RET") list("U1" "48" "V3V3" "L09_QFP120X030_M05") list("U1" "47" "GND" "L09_QFP120X030_M05") list("U1" "46" "GPIO_PB9" "L09_QFP120X030_M05") list("U1" "45" "GPIO_PB8" "L09_QFP120X030_M05") list("U1" "44" "BOOT0" "L09_QFP120X030_M05") list("U1" "43" "I2C_SDA" "L09_QFP120X030_M05") list("U1" "42" "I2C_SCL" "L09_QFP120X030_M05") list("U1" "41" "GPIO_PB5" "L09_QFP120X030_M05") list("U1" "40" "GPIO_PB4" "L09_QFP120X030_M05") list("U1" "39" "SWO" "L09_QFP120X030_M05") list("U1" "38" "GPIO_PA15" "L09_QFP120X030_M05") list("U1" "37" "SWCLK" "L09_QFP120X030_M05") list("U1" "36" "V3V3" "L09_QFP120X030_M05") list("U1" "35" "GND" "L09_QFP120X030_M05") list("U1" "34" "SWDIO" "L09_QFP120X030_M05") list("U1" "33" "PA12_SHARED" "L09_QFP120X030_M05") list("U1" "32" "PA11_SHARED" "L09_QFP120X030_M05") list("U1" "31" "PA10_UART_RX" "L09_QFP120X030_M05") list("U1" "30" "PA9_UART_TX" "L09_QFP120X030_M05") list("U1" "29" "USB_ATTACH_N" "L09_QFP120X030_M05") list("U1" "28" "GPIO_PB15" "L09_QFP120X030_M05") list("U1" "27" "GPIO_PB14" "L09_QFP120X030_M05") list("U1" "26" "GPIO_PB13" "L09_QFP120X030_M05") list("U1" "25" "GPIO_PB12" "L09_QFP120X030_M05") list("U1" "24" "V3V3" "L09_QFP120X030_M05") list("U1" "23" "GND" "L09_QFP120X030_M05") list("U1" "22" "GPIO_PB11" "L09_QFP120X030_M05") list("U1" "21" "GPIO_PB10" "L09_QFP120X030_M05") list("U1" "20" "BOOT1" "L09_QFP120X030_M05") list("U1" "19" "GPIO_PB1" "L09_QFP120X030_M05") list("U1" "18" "VBUS_PRESENT_N" "L09_QFP120X030_M05") list("U1" "17" "PA7_SPI_MOSI" "L09_QFP120X030_M05") list("U1" "16" "PA6_SPI_MISO" "L09_QFP120X030_M05") list("U1" "15" "PA5_SPI_SCK" "L09_QFP120X030_M05") list("U1" "14" "PA4_SPI_NSS" "L09_QFP120X030_M05") list("U1" "13" "GPIO_PA3" "L09_QFP120X030_M05") list("U1" "12" "GPIO_PA2" "L09_QFP120X030_M05") list("U1" "11" "GPIO_PA1" "L09_QFP120X030_M05") list("U1" "10" "ADC0" "L09_QFP120X030_M05") list("U1" "9" "VDDA" "L09_QFP120X030_M05") list("U1" "8" "GND" "L09_QFP120X030_M05") list("U1" "7" "NRST" "L09_QFP120X030_M05") list("U1" "6" "OSC_OUT" "L09_QFP120X030_M05") list("U1" "5" "OSC_IN" "L09_QFP120X030_M05") list("U1" "4" "GPIO_PC15" "L09_QFP120X030_M05") list("U1" "3" "GPIO_PC14" "L09_QFP120X030_M05") list("U1" "2" "GPIO_PC13" "L09_QFP120X030_M05") list("U1" "1" "V3V3" "L09_QFP120X030_M05") list("C16" "1" "V3V3" "SMD_40X50RET") list("C16" "2" "GND" "SMD_40X50RET") list("C20" "1" "VDDA" "SMD_40X50RET") list("C20" "2" "GND" "SMD_40X50RET") list("C8" "1" "V5" "SMD_40X50RET") list("C8" "2" "GND" "SMD_40X50RET") list("C9" "1" "V3V3" "SMD_40X50RET") list("C9" "2" "GND" "SMD_40X50RET") list("Y1" "4" "GND" "DE_SMD180X120") list("Y1" "3" "XTAL_OUT" "DE_SMD180X120") list("Y1" "2" "GND" "DE_SMD180X120") list("Y1" "1" "OSC_IN" "DE_SMD180X120") list("J7" "2" "GND" "VIA_1D0_1D54") list("J7" "1" "NRST" "VIA_1D0_1D54S") list("J8" "2" "BOOT0" "VIA_1D0_1D54") list("J8" "1" "BOOT_SERVICE" "VIA_1D0_1D54S") list("J10" "2" "GND" "VIA_1D0_1D54") list("J10" "1" "ADC_IN" "VIA_1D0_1D54S") list("J1" "2" "GND" "VIA_1D0_1D54") list("J1" "1" "VIN_RAW" "VIA_1D0_1D54S") list("D1" "2" "VIN_FUSED" "PAD67X78") list("D1" "1" "VIN_PROT" "PAD67X78") list("C1" "2" "GND" "VIA_1D0_1D54") list("C1" "1" "VIN_PROT" "VIA_1D0_1D54S") list("C2" "1" "VIN_PROT" "SMD_60X63RET") list("C2" "2" "GND" "SMD_60X63RET") list("C5" "1" "V5" "SMD_60X63RET") list("C5" "2" "GND" "SMD_60X63RET") list("C6" "1" "V5" "SMD_60X63RET") list("C6" "2" "GND" "SMD_60X63RET") list("R15" "1" "CAN_H" "SMD_60X63RET") list("R15" "2" "CAN_L" "SMD_60X63RET") list("U2" "6" "BUCK_BOOT" "PAD_0D6_1D1O") list("U2" "5" nil "PAD_0D6_1D1O") list("U2" "4" "BUCK_FB" "PAD_0D6_1D1O") list("U2" "3" "VIN_PROT" "PAD_0D6_1D1O") list("U2" "2" "BUCK_SW" "PAD_0D6_1D1O") list("U2" "1" "GND" "PAD_0D6_1D1O") list("U4" "6" "USB_DP" "PAD_0D6_1D1O") list("U4" "5" "USB_VBUS" "PAD_0D6_1D1O") list("U4" "4" "USB_DM" "PAD_0D6_1D1O") list("U4" "3" "USB_DM" "PAD_0D6_1D1O") list("U4" "2" "GND" "PAD_0D6_1D1O") list("U4" "1" "USB_DP" "PAD_0D6_1D1O") list("L1" "2" "V5" "DE_SMD143X550") list("L1" "1" "BUCK_SW" "DE_SMD143X550") list("U3" "1" "V5" "PAD_1D3_0D6") list("U3" "2" "GND" "PAD_1D3_0D6") list("U3" "3" "V5" "PAD_1D3_0D6") list("U3" "4" nil "PAD_1D3_0D6") list("U3" "5" "V3V3" "PAD_1D3_0D6") list("Q1" "1" "VBUS_GATE" "PAD_36_47") list("Q1" "2" "GND" "PAD_36_47") list("Q1" "3" "VBUS_PRESENT_N" "PAD_36_47") list("Q2" "1" "USB_ATTACH_N" "PAD_36_47") list("Q2" "2" "V3V3" "PAD_36_47") list("Q2" "3" "USB_PULLUP_SRC" "PAD_36_47") list("U5" "1" "CAN_TXD" "RE60X24") list("U5" "2" "GND" "RE60X24") list("U5" "3" "V3V3" "RE60X24") list("U5" "4" "CAN_RXD" "RE60X24") list("U5" "5" nil "RE60X24") list("U5" "6" "CAN_L" "RE60X24") list("U5" "7" "CAN_H" "RE60X24") list("U5" "8" nil "RE60X24")))
 hiProof(f "C10.1" "J2.A4_B9" t)
 hiProof(f "C10.1" "J2.B4_A9" t)
 hiProof(f "C10.1" "R7.1" t)
 hiProof(f "C10.1" "U4.5" t)
 hiProof(f "J6.2" "R21.2" t)
 hiProof(f "R13.1" "R6.1" t)
 hiProof(f "R13.1" "U1.32" t)
 hiProof(f "C4.2" "L1.1" t)
 hiProof(f "C4.2" "U2.2" t)
 hiProof(f "J2.A6" "J2.B6" t)
 hiProof(f "J2.A6" "R11.2" t)
 hiProof(f "J2.A6" "R5.2" t)
 hiProof(f "J2.A6" "U4.1" t)
 hiProof(f "J2.A6" "U4.6" t)
 hiProof(f "Q2.1" "R10.2" t)
 hiProof(f "R14.2" "U5.1" t)
 hiProof(f "J3.2" "R15.2" t)
 hiProof(f "J3.2" "U5.6" t)
 hiProof(f "J2.B5" "R4.1" t)
 hiProof(f "J3.1" "R15.1" t)
 hiProof(f "J3.1" "U5.7" t)
 hiProof(f "R23.1" "R25.2" t)
 hiProof(f "R23.1" "U1.14" t)
 hiProof(f "R31.1" "U1.6" t)
 hiProof(f "J2.A5" "R3.1" t)
 hiProof(f "R12.1" "R5.1" t)
 hiProof(f "R12.1" "U1.33" t)
 hiProof(f "D1.2" "F1.2" t)
 hiProof(f "C1.2" "C10.2" t)
 hiProof(f "C1.2" "C11.2" t)
 hiProof(f "C1.2" "C12.2" t)
 hiProof(f "C1.2" "C13.2" t)
 hiProof(f "C1.2" "C14.2" t)
 hiProof(f "C1.2" "C15.2" t)
 hiProof(f "C1.2" "C16.2" t)
 hiProof(f "C1.2" "C17.2" t)
 hiProof(f "C1.2" "C18.2" t)
 hiProof(f "C1.2" "C19.2" t)
 hiProof(f "C1.2" "C2.2" t)
 hiProof(f "C1.2" "C20.2" t)
 hiProof(f "C1.2" "C21.2" t)
 hiProof(f "C1.2" "C22.2" t)
 hiProof(f "C1.2" "C23.2" t)
 hiProof(f "C1.2" "C24.2" t)
 hiProof(f "C1.2" "C3.2" t)
 hiProof(f "C1.2" "C5.2" t)
 hiProof(f "C1.2" "C6.2" t)
 hiProof(f "C1.2" "C8.2" t)
 hiProof(f "C1.2" "C9.2" t)
 hiProof(f "C1.2" "J1.2" t)
 hiProof(f "C1.2" "J10.2" t)
 hiProof(f "C1.2" "J11.2" t)
 hiProof(f "C1.2" "J12.2" t)
 hiProof(f "C1.2" "J13.2" t)
 hiProof(f "C1.2" "J2.SH1" t)
 hiProof(f "C1.2" "J2.SH2" t)
 hiProof(f "C1.2" "J2.SH3" t)
 hiProof(f "C1.2" "J2.SH4" t)
 hiProof(f "C1.2" "J3.3" t)
 hiProof(f "C1.2" "J4.4" t)
 hiProof(f "C1.2" "J5.4" t)
 hiProof(f "C1.2" "J6.6" t)
 hiProof(f "C1.2" "J7.2" t)
 hiProof(f "C1.2" "J9.2" t)
 hiProof(f "C1.2" "R2.2" t)
 hiProof(f "C1.2" "R28.2" t)
 hiProof(f "C1.2" "R3.2" t)
 hiProof(f "C1.2" "R4.2" t)
 hiProof(f "C1.2" "U1.23" t)
 hiProof(f "C1.2" "U1.35" t)
 hiProof(f "C1.2" "U1.47" t)
 hiProof(f "C1.2" "U1.8" t)
 hiProof(f "C1.2" "U2.1" t)
 hiProof(f "C1.2" "U3.2" t)
 hiProof(f "C1.2" "U4.2" t)
 hiProof(f "C1.2" "U5.2" t)
 hiProof(f "C1.2" "Y1.2" t)
 hiProof(f "C1.2" "Y1.4" t)
 hiProof(f "C24.1" "R32.2" t)
 hiProof(f "C24.1" "U1.10" t)
 hiProof(f "J4.3" "R18.1" t)
 hiProof(f "C4.1" "U2.6" t)
 hiProof(f "C11.1" "C12.1" t)
 hiProof(f "C11.1" "C13.1" t)
 hiProof(f "C11.1" "C14.1" t)
 hiProof(f "C11.1" "C15.1" t)
 hiProof(f "C11.1" "C16.1" t)
 hiProof(f "C11.1" "C17.1" t)
 hiProof(f "C11.1" "C9.1" t)
 hiProof(f "C11.1" "J11.1" t)
 hiProof(f "C11.1" "J12.1" t)
 hiProof(f "C11.1" "J13.1" t)
 hiProof(f "C11.1" "J4.1" t)
 hiProof(f "C11.1" "J5.1" t)
 hiProof(f "C11.1" "J6.1" t)
 hiProof(f "C11.1" "J9.1" t)
 hiProof(f "C11.1" "Q2.2" t)
 hiProof(f "C11.1" "R10.1" t)
 hiProof(f "C11.1" "R14.1" t)
 hiProof(f "C11.1" "R18.2" t)
 hiProof(f "C11.1" "R19.1" t)
 hiProof(f "C11.1" "R20.1" t)
 hiProof(f "C11.1" "R25.1" t)
 hiProof(f "C11.1" "R26.1" t)
 hiProof(f "C11.1" "R27.1" t)
 hiProof(f "C11.1" "R30.1" t)
 hiProof(f "C11.1" "R9.1" t)
 hiProof(f "C11.1" "U1.1" t)
 hiProof(f "C11.1" "U1.24" t)
 hiProof(f "C11.1" "U1.36" t)
 hiProof(f "C11.1" "U1.48" t)
 hiProof(f "C11.1" "U3.5" t)
 hiProof(f "C11.1" "U5.3" t)
 hiProof(f "Q2.3" "R11.1" t)
 hiProof(f "R24.1" "U1.16" t)
 hiProof(f "C18.1" "C19.1" t)
 hiProof(f "C18.1" "C20.1" t)
 hiProof(f "C18.1" "R26.2" t)
 hiProof(f "C18.1" "U1.9" t)
 hiProof(f "Q1.3" "R9.2" t)
 hiProof(f "F1.1" "J1.1" t)
 hiProof(f "J6.5" "R23.2" t)
 hiProof(f "C5.1" "C6.1" t)
 hiProof(f "C5.1" "C7.1" t)
 hiProof(f "C5.1" "C8.1" t)
 hiProof(f "C5.1" "L1.2" t)
 hiProof(f "C5.1" "R1.1" t)
 hiProof(f "C5.1" "U3.1" t)
 hiProof(f "C5.1" "U3.3" t)
 hiProof(f "J6.3" "R22.2" t)
 hiProof(f "J6.4" "R24.2" t)
 hiProof(f "C7.2" "R1.2" t)
 hiProof(f "C7.2" "R2.1" t)
 hiProof(f "C7.2" "U2.4" t)
 hiProof(f "J10.1" "R32.1" t)
 hiProof(f "R21.1" "U1.15" t)
 hiProof(f "R22.1" "U1.17" t)
 hiProof(f "C23.1" "R31.2" t)
 hiProof(f "C23.1" "Y1.3" t)
 hiProof(f "J2.A7" "J2.B7" t)
 hiProof(f "J2.A7" "R6.2" t)
 hiProof(f "J2.A7" "U4.3" t)
 hiProof(f "J2.A7" "U4.4" t)
 hiProof(f "Q1.1" "R7.2" t)
 hiProof(f "Q1.1" "R8.1" t)
 hiProof(f "C22.1" "U1.5" t)
 hiProof(f "C22.1" "Y1.1" t)
 hiProof(f "C1.1" "C2.1" t)
 hiProof(f "C1.1" "C3.1" t)
 hiProof(f "C1.1" "D1.1" t)
 hiProof(f "C1.1" "U2.3" t)
 hiProof(f "C21.1" "U1.7" t)
 fprintf(f "HI_CUMULATIVE_BASELINE_PHYSICAL_PIN_PROOFS_COMPLETE positiveEdges=152 readOnly=t storedDRC=%d fullDRCRecompute=NOT_REQUESTED final197AllNetProofs=NOT_REQUESTED online=%L\n" length(axlDBGetDesign()->drcs) axlDBControl('drcEnable)) close(f) t))
