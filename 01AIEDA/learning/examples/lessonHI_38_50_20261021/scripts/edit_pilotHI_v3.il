procedure(hiViaMaskProbe(out)
 let((f seen v pad ps)
  f=outfile(strcat(out "/hi_via_mask_probe.tsv"))
  fprintf(f "object\tpadstack\txy\tlayer\tfigure\tbbox\tpadAttrs\n")
  seen=nil
  foreach(v axlExtractMap("C:/Program0/Cadence/SPB172/share/pcb/text/views/fgeo_bv.txt" nil)
   when(equal(v->objType "via") && !member(v seen)
    seen=cons(v seen)
    foreach(layer list("VIA CLASS/SOLDERMASK_TOP" "VIA CLASS/SOLDERMASK_BOTTOM" "PIN/SOLDERMASK_TOP" "PIN/SOLDERMASK_BOTTOM")
     pad=axlDBGetPad(v layer "REGULAR")
     fprintf(f "%L\t%L\t%L\t%L\t%L\t%L\t%L\n" v v->name v->xy layer if(pad then pad->figureName else nil) if(pad then pad->bBox else nil) if(pad then pad->?? else nil)))))
  fprintf(f "HI_VIA_MASK_PROBE_COMPLETE count=%d\n" length(seen))
  close(f) t))
procedure(hiEditPilot(out lib)
 let((f mark initialUnc net start cap routes ret a b c gnd shape path void graph seg rippedPoints rippedWidth beforeCount afterCount)
  hiViaMaskProbe(out)
  f=outfile(strcat(out "/hi_route_edit_pilot.txt"))
  axlDBRefreshId(nil)
  net=axlDBFindByName('net "V3V3") initialUnc=net->unconnected
  fprintf(f "BASELINE_V3V3_UNCONNECTED=%L\n" initialUnc)
  mark=axlDBTransactionStart()
  unless(mark error("Cannot start HI pilot transaction\n"))
  start=gPin("U1" "24") cap=gPin("C13" "1")
  routes=setof(x axlDBGetConnect(start t) member(x->objType list("path" "cline")))
  fprintf(f "EXISTING_PIN_ATTACHED_ROUTES=%L\n" routes)
  unless(length(routes)==1 error("Ambiguous source local route for controlled ripup\n"))
  fprintf(f "RIPUP_PATH_BEFORE=%L\n" car(routes)->??)
  unless(axlDeleteObject(car(routes)) error("Controlled cline ripup failed\n"))
  axlDBRefreshId(nil)
  graph=gConnectedObjects(gPin("U1" "24"))
  fprintf(f "AFTER_RIPUP nativeUnconnected=%L targetReached=%L\n" axlDBFindByName('net "V3V3")->unconnected if(member(gPin("C13" "1") graph) then t else nil))
  when(member(gPin("C13" "1") graph) error("Ripup did not disconnect controlled test pin\n"))
  gRouteNative("V3V3" list(35.75:24.25 34.95:24.25 34.55:23.85 33.9:23.85 33.4:23.7) list(0.25 0.25 0.60 0.60) "ETCH/TOP" f "HI_REBUILD_C13_NEW_WIDE_CORNER")
  axlDBRefreshId(nil)
  gConnectivityProof(f "U1" "24" "C13" "1" nil)
  unless(equal(axlDBFindByName('net "V3V3")->unconnected initialUnc) error("Reroute changed V3V3 required joins\n"))
  path=car(setof(x axlDBGetConnect(gPin("U1" "24") t) equal(x->objType "path")))
  seg=car(path->segments) rippedPoints=seg->startEnd rippedWidth=seg->width
  beforeCount=length(setof(x axlExtractMap("C:/Program0/Cadence/SPB172/share/pcb/text/views/fgeo_bv.txt" nil) equal(x->objType "line") && equal(x->layer "ETCH/TOP") && x->net && equal(x->net->name "V3V3")))
  fprintf(f "SINGLE_SEGMENT_BEFORE=%L points=%L width=%L count=%d\n" seg->?? rippedPoints rippedWidth beforeCount)
  unless(axlDeleteObject(seg) error("Cannot delete single cline segment\n"))
  axlDBRefreshId(nil)
  afterCount=length(setof(x axlExtractMap("C:/Program0/Cadence/SPB172/share/pcb/text/views/fgeo_bv.txt" nil) equal(x->objType "line") && equal(x->layer "ETCH/TOP") && x->net && equal(x->net->name "V3V3")))
  fprintf(f "SINGLE_SEGMENT_AFTER count=%d targetConnected=%L\n" afterCount if(member(gPin("C13" "1") gConnectedObjects(gPin("U1" "24"))) then t else nil))
  unless(afterCount==beforeCount-1 && !member(gPin("C13" "1") gConnectedObjects(gPin("U1" "24"))) error("Single-segment delete was not scoped or did not disconnect\n"))
  gRouteNative("V3V3" rippedPoints list(rippedWidth) "ETCH/TOP" f "HI_RECREATE_SINGLE_SEGMENT")
  axlDBRefreshId(nil)
  gConnectivityProof(f "U1" "24" "C13" "1" nil)

  a=car(axlDBCreateVia("L28_VIA030_C060" 40:50 "V3V3" nil 0.0 nil))
  b=car(axlDBCreateVia("L28_VIA030_C060" 42:50 "V3V3" nil 0.0 nil))
  c=car(axlDBCreateVia("L28_VIA030_C060" 45:50 "V3V3" nil 0.0 nil))
  gnd=car(axlDBCreateVia("L28_VIA030_C060" 42:51 "GND" nil 0.0 nil))
  unless(a && b && c && gnd error("Pilot vias failed\n"))
  gRouteNative("V3V3" list(40:50 42:50) list(0.6) "ETCH/TOP" f "HI_PILOT_TOP")
  gRouteNative("V3V3" list(42:50 45:50) list(0.6) "ETCH/BOTTOM" f "HI_PILOT_LAYER_CHANGE")
  axlDBRefreshId(nil)
  graph=gConnectedObjects(a)
  fprintf(f "NATIVE_LAYER_CHANGE_A_TO_C=%L OBJECTS=%d RETURN_VIA=%L\n" if(member(c graph) then t else nil) length(graph) gnd->??)
  unless(member(c graph) error("TOP-via-BOTTOM graph not connected\n"))
  path=axlPathStart(list(50:48 55:48 55:52 50:52 50:48) 0.0)
  shape=axlDBCreateOpenShape(path t "ETCH/TOP" "GND")
  unless(shape error("Static local plane trial failed\n"))
  path=axlPathStart(list(53:49 54:49 54:51 53:51 53:49) 0.0)
  void=axlDBCreateVoid(shape path)
  unless(void error("Permanent void create failed\n"))
  ret=axlDBCreateCloseShape(shape t)
  unless(ret error("Closing plane with permanent void failed\n"))
  shape=car(ret)
  axlDBRefreshId(nil)
  fprintf(f "VOID_READ shape=%L void=%L pointInCopper=%L pointInVoid=%L\n" shape->?? void->?? axlGeoPointInShape(52:50 shape t) axlGeoPointInShape(53.5:50 shape t))
  unless(axlGeoPointInShape(52:50 shape t) && !axlGeoPointInShape(53.5:50 shape t) error("Actual copper/void containment failed\n"))
  axlShapeDynamicUpdate(nil t)
  axlDRCUpdate(t) f29DumpDRC(f "HI_PILOT_WITH_LAYER_CHANGE_AND_VOID")
  unless(length(axlDBGetDesign()->drcs)==0 error("HI controlled edit trial DRC not clean\n"))
  unless(axlDBTransactionRollback(mark) error("Cannot rollback HI edit pilot\n"))
  axlDBRefreshId(nil)
  axlShapeDynamicUpdate(nil nil)
  axlDRCUpdate(t) f29DumpDRC(f "HI_PILOT_ROLLBACK")
  unless(equal(axlDBFindByName('net "V3V3")->unconnected initialUnc) && length(axlDBGetDesign()->drcs)==0 error("Rollback not clean/exact\n"))
  fprintf(f "HI_ROUTE_EDIT_PILOT_COMPLETE_NO_SAVE\n") close(f)
  gSnapshot(out lib)
  hiNetworkInventory(out)
  t))
