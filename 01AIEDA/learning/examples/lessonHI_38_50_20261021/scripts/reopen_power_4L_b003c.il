procedure(hiReadbackProofs()
 let((f)
  f=outfile("D:/001DIY/005lib/01AIEDA/learning/examples/lessonHI_38_50_20261021/logs/reopen_power_4L_b003c/hi_reopen_endpoint_proofs.txt")
  hiRegistry=nil
  hiNodeDefinitions=list(list("STAR_C9_FEED" "V3V3" "TOP" list(29.8 30.95) "point") list("V_HI_V3_SOURCE" "V3V3" "TOP" list(30.7 32.0) "via") list("STAR_BOTTOM_FEED" "V3V3" "BOTTOM" list(30.7 32.0) "point") list("V_HI_V3_STAR" "V3V3" "TOP" list(37.0 24.0) "via") list("STAR_SOUTH_BUS" "V3V3" "TOP" list(37.0 24.0) "point") list("STAR_RIGHT_BUS" "V3V3" "TOP" list(43.0 24.0) "point") list("STAR_U1_24" "V3V3" "TOP" list(35.75 24.25) "point") list("STAR_U1_36" "V3V3" "TOP" list(42.75 22.75) "point") list("STAR_U1_48" "V3V3" "TOP" list(44.25 29.75) "point") list("STAR_U1_VBAT" "V3V3" "TOP" list(42.75 31.25) "point") list("STAR_2L_RETURN_STRAP" "GND" "TOP" list(32.45 25.2748) "point") list("V3_VDDA_PRE_FILTER" "V3V3" "TOP" list(29.8 30.95) "point") list("NODE_V3_RIGHT_SOUTH" "V3V3" "TOP" list(43.0 24.0) "point") list("NODE_V3_RIGHT_NORTH" "V3V3" "TOP" list(43.0 29.9) "point") list("G31_C13_GND_VIA" "GND" "TOP" list(32.45 25.2748) "via"))
  hiBindExistingVia(f "V_HI_V3_SOURCE" "V3V3" list(30.7 32.0) "L28_VIA030_C060")
  hiBindExistingVia(f "V_HI_V3_STAR" "V3V3" list(37.0 24.0) "L28_VIA030_C060")
  hiProof(f "C9.1" "V_HI_V3_SOURCE" t)
  hiProof(f "V_HI_V3_SOURCE" "V_HI_V3_STAR" t)
  hiProof(f "V_HI_V3_STAR" "NODE_V3_RIGHT_SOUTH" t)
  hiProof(f "NODE_V3_RIGHT_SOUTH" "NODE_V3_RIGHT_NORTH" t)
  hiProof(f "U1.24" "V_HI_V3_STAR" t)
  hiProof(f "U1.36" "STAR_SOUTH_BUS" t)
  hiProof(f "U1.48" "STAR_RIGHT_BUS" t)
  hiProof(f "U1.1" "STAR_RIGHT_BUS" t)
  hiProof(f "G31_C13_GND_VIA" "C9.2" t)
  hiProof(f "C9.1" "R26.1" t)
  fprintf(f "HI_REOPEN_ALL_ENDPOINTS_COMPLETE\n") close(f) t))
