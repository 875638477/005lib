procedure(hiBatchProgram()
 let((f)
  f=outfile("D:/001DIY/005lib/01AIEDA/learning/examples/lessonHI_38_50_20261021/logs/power_2L_b003c/hi_batch_execution.txt")
  hiRegistry=nil
  hiNodeDefinitions=list(list("STAR_C9_FEED" "V3V3" "TOP" list(29.8 30.95) "point") list("V_HI_V3_SOURCE" "V3V3" "TOP" list(30.7 32.0) "via") list("STAR_BOTTOM_FEED" "V3V3" "BOTTOM" list(30.7 32.0) "point") list("V_HI_V3_STAR" "V3V3" "TOP" list(37.0 24.0) "via") list("STAR_SOUTH_BUS" "V3V3" "TOP" list(37.0 24.0) "point") list("STAR_RIGHT_BUS" "V3V3" "TOP" list(43.0 24.0) "point") list("STAR_U1_24" "V3V3" "TOP" list(35.75 24.25) "point") list("STAR_U1_36" "V3V3" "TOP" list(42.75 22.75) "point") list("STAR_U1_48" "V3V3" "TOP" list(44.25 29.75) "point") list("STAR_U1_VBAT" "V3V3" "TOP" list(42.75 31.25) "point") list("STAR_2L_RETURN_STRAP" "GND" "TOP" list(32.45 25.2748) "point") list("V3_VDDA_PRE_FILTER" "V3V3" "TOP" list(29.8 30.95) "point") list("NODE_V3_RIGHT_SOUTH" "V3V3" "TOP" list(43.0 24.0) "point") list("NODE_V3_RIGHT_NORTH" "V3V3" "TOP" list(43.0 29.9) "point") list("G31_C13_GND_VIA" "GND" "TOP" list(32.45 25.2748) "via"))
  hiCSet(f 'physical "HI_U1_INNER_LEFT_P_2L" "HI2L_P_POWER_LV" list(list('necklength_max "1.4 MM")))
  hiCSet(f 'spacing "HI_U1_INNER_LEFT_S_POWER_2L" "HI2L_S_POWER_LV" list(list('smdpin_line "0.2 MM") list('line_line "0.2 MM")))
  hiCSet(f 'spacing "HI_U1_INNER_LEFT_S_GROUND_2L" "HI2L_S_GROUND" list(list('smdpin_line "0.2 MM") list('line_line "0.2 MM")))
  hiRegion(f "HI_U1_INNER_LEFT" "TOP" list(list(35.1 23.8) list(37.3 23.8) list(37.3 25.1) list(35.1 25.1)) list(list("HI2L_POWER_LV_P" 'physical "HI_U1_INNER_LEFT_P_2L") list("HI2L_POWER_LV_S" 'spacing "HI_U1_INNER_LEFT_S_POWER_2L") list("HI2L_GROUND_S" 'spacing "HI_U1_INNER_LEFT_S_GROUND_2L")))
  hiCSet(f 'physical "HI_U1_INNER_SOUTH_P_2L" "HI2L_P_POWER_LV" list(list('necklength_max "1.4 MM")))
  hiCSet(f 'spacing "HI_U1_INNER_SOUTH_S_POWER_2L" "HI2L_S_POWER_LV" list(list('smdpin_line "0.2 MM") list('line_line "0.2 MM")))
  hiCSet(f 'spacing "HI_U1_INNER_SOUTH_S_GROUND_2L" "HI2L_S_GROUND" list(list('smdpin_line "0.2 MM") list('line_line "0.2 MM")))
  hiRegion(f "HI_U1_INNER_SOUTH" "TOP" list(list(41.95 22.1) list(43.55 22.1) list(43.55 24.3) list(41.95 24.3)) list(list("HI2L_POWER_LV_P" 'physical "HI_U1_INNER_SOUTH_P_2L") list("HI2L_POWER_LV_S" 'spacing "HI_U1_INNER_SOUTH_S_POWER_2L") list("HI2L_GROUND_S" 'spacing "HI_U1_INNER_SOUTH_S_GROUND_2L")))
  hiCSet(f 'physical "HI_U1_INNER_NE_P_2L" "HI2L_P_POWER_LV" list(list('necklength_max "1.5 MM")))
  hiCSet(f 'spacing "HI_U1_INNER_NE_S_POWER_2L" "HI2L_S_POWER_LV" list(list('smdpin_line "0.2 MM") list('line_line "0.2 MM")))
  hiCSet(f 'spacing "HI_U1_INNER_NE_S_GROUND_2L" "HI2L_S_GROUND" list(list('smdpin_line "0.2 MM") list('line_line "0.2 MM")))
  hiRegion(f "HI_U1_INNER_NE" "TOP" list(list(42.5 28.85) list(44.95 28.85) list(44.95 31.95) list(42.5 31.95)) list(list("HI2L_POWER_LV_P" 'physical "HI_U1_INNER_NE_P_2L") list("HI2L_POWER_LV_S" 'spacing "HI_U1_INNER_NE_S_POWER_2L") list("HI2L_GROUND_S" 'spacing "HI_U1_INNER_NE_S_GROUND_2L")))
  hiRoute(f "STAR_C9_FEED" "V3V3" "TOP" list(list(29.8 30.95) list(30.7 31.85) list(30.7 32.0)) list(0.6 0.6))
  hiVia(f "V_HI_V3_SOURCE" "V3V3" list(30.7 32.0) "L28_VIA030_C060")
  hiRoute(f "STAR_BOTTOM_FEED" "V3V3" "BOTTOM" list(list(30.7 32.0) list(30.7 24.0) list(37.0 24.0)) list(0.6 0.6))
  hiVia(f "V_HI_V3_STAR" "V3V3" list(37.0 24.0) "L28_VIA030_C060")
  hiRoute(f "STAR_SOUTH_BUS" "V3V3" "TOP" list(list(37.0 24.0) list(43.0 24.0)) list(0.6))
  hiRoute(f "STAR_RIGHT_BUS" "V3V3" "TOP" list(list(43.0 24.0) list(43.0 29.9)) list(0.6))
  hiRoute(f "STAR_U1_24" "V3V3" "TOP" list(list(35.75 24.25) list(37.0 24.25) list(37.0 24.0)) list(0.25 0.6))
  hiRoute(f "STAR_U1_36" "V3V3" "TOP" list(list(42.75 22.75) list(42.75 24.0)) list(0.25))
  hiRoute(f "STAR_U1_48" "V3V3" "TOP" list(list(44.25 29.75) list(43.0 29.75)) list(0.25))
  hiRoute(f "STAR_U1_VBAT" "V3V3" "TOP" list(list(42.75 31.25) list(42.75 30.15) list(43.0 29.9)) list(0.25 0.25))
  hiRoute(f "STAR_2L_RETURN_STRAP" "GND" "TOP" list(list(32.45 25.2748) list(31.2 25.2748) list(30.7 25.7748) list(30.7 29.0) list(29.8 29.0)) list(0.6 0.6 0.6 0.6))
  hiRoute(f "V3_VDDA_PRE_FILTER" "V3V3" "TOP" list(list(29.8 30.95) list(28.4 32.35) list(22.0 32.35) list(22.0 37.0) list(29.5 37.0)) list(0.6 0.6 0.6 0.6))
  hiFinalize(f "D:/001DIY/005lib/01AIEDA/learning/examples/lessonHI_38_50_20261021/logs/power_2L_b003c" "D:/001DIY/005lib/01AIEDA/learning/examples/lessonHI_38_50_20261021/native/HI_2L_power_2L_b003c.brd" "D:/001DIY/005lib/01AIEDA/learning/examples/lessonHI_38_50_20261021/library" list(list("C9.1" "V_HI_V3_SOURCE" t) list("V_HI_V3_SOURCE" "V_HI_V3_STAR" t) list("V_HI_V3_STAR" "NODE_V3_RIGHT_SOUTH" t) list("NODE_V3_RIGHT_SOUTH" "NODE_V3_RIGHT_NORTH" t) list("U1.24" "V_HI_V3_STAR" t) list("U1.36" "STAR_SOUTH_BUS" t) list("U1.48" "STAR_RIGHT_BUS" t) list("U1.1" "STAR_RIGHT_BUS" t) list("G31_C13_GND_VIA" "C9.2" t) list("C9.1" "R26.1" t)))
  t))
