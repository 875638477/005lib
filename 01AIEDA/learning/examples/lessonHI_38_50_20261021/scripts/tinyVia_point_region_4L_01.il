procedure(hiTinyViaApprovalPilot(out)
 let((f mark initial net nc parent inside outside countIn countOut originalVias layers r shape tbl)
  f=outfile(strcat(out "/hi_tiny_via_approval.txt"))
  initial=length(hiAllVias()) net=axlDBFindByName('net "GPIO_PB12") nc=axlNetClassGet(net 'physical t)
  parent="P_SIGNAL_020"
  originalVias=axlCNSGetPhysical(parent "TOP" 'vias)
  fprintf(f "INITIAL viaCount=%d class=%L directProps=%L originalViaList=%L modes=%L\n" initial nc->name axlDBGetProperties(net) originalVias axlCNSPhysicalModeGet('all))
  unless(equal(nc->name "NC_DIGITAL_GENERAL_P") error("Unexpected pilot physical class; abort\n"))
  mark=axlDBTransactionStart()
  unwindProtect(progn(
   axlDBControl('drcEnable nil)
   axlSetVariable("padpath" list("D:/001DIY/005lib/01AIEDA/learning/examples/lessonHI_38_50_20261021/library"))
   unless(axlLoadPadstack("HI_VIA026_C052_TENT") error("Cannot load private via definition\n"))
   hiRegistry=nil
   hiCSet(f 'physical "HI_PILOT_TINY_APPROVAL" parent list(list('vias "L28_VIA030_C060:HI_VIA026_C052_TENT")))
   hiRegion(f "HI_PILOT_TINY_REGION" "TOP" list(list(55.99 45.99) list(56.01 45.99) list(56.01 46.01) list(55.99 46.01)) list(list(nc->name 'physical "HI_PILOT_TINY_APPROVAL" nil)))
   hiVia(f "INSIDE" "GPIO_PB12" list(56.0 46.0) "HI_VIA026_C052_TENT")
   hiVia(f "OUTSIDE" "GPIO_PB12" list(58.0 46.0) "HI_VIA026_C052_TENT")
   inside=hiUniqueVia("GPIO_PB12" list(56.0 46.0) "HI_VIA026_C052_TENT") outside=hiUniqueVia("GPIO_PB12" list(58.0 46.0) "HI_VIA026_C052_TENT")
   axlDBControl('drcEnable t)
   countIn=axlDRCItem(nil inside) countOut=axlDRCItem(nil outside)
   fprintf(f "TOP_REGION_ONLY insideDRC=%L outsideDRC=%L inside=%L outside=%L\n" countIn countOut inside->?? outside->??)
   foreach(d axlDBGetDesign()->drcs fprintf(f "DRC_TOP_ONLY %L\n" d->??))
   unless(numberp(countIn) && numberp(countOut) && countOut>0 error("Outside private via approval negative not detected\n"))
   when(countIn>0
    axlDBControl('drcEnable nil) r=car(setof(x axlDBGetDesign()->region equal(x->name "HI_PILOT_TINY_REGION")))
    foreach(layer axlGetParam("paramLayerGroup:ETCH")->groupMembers
     unless(equal(layer "TOP")
      shape=car(axlDBCreateShape(hiClosedPath(list(list(55.99 45.99) list(56.01 45.99) list(56.01 46.01) list(55.99 46.01))) nil strcat("CONSTRAINT REGION/" layer)))
      unless(shape && axlRegionAdd(r shape) error("Cannot extend pilot region to actual copper layer\n"))))
    axlCNSMapUpdate() axlDBControl('drcEnable t)
    countIn=axlDRCItem(nil inside) countOut=axlDRCItem(nil outside)
    fprintf(f "ALL_ACTUAL_CONDUCTOR_LAYERS insideDRC=%L outsideDRC=%L region=%L\n" countIn countOut r->??)
    foreach(d axlDBGetDesign()->drcs fprintf(f "DRC_ALL_LAYERS %L\n" d->??)))
   unless(countIn==0 && countOut>0 error("Finite private-via physical approval did not isolate inside/outside\n"))
   t) progn(unless(axlDBTransactionRollback(mark) error("Private via region pilot rollback failed\n")) axlDBControl('drcEnable t)))
  unless(initial==length(hiAllVias()) && equal(originalVias axlCNSGetPhysical(parent "TOP" 'vias)) error("Pilot rollback did not restore original via count/approval\n"))
  fprintf(f "ROLLBACK_RESTORED viaCount=%d originalViaList=%L online=%L\nHI_TINY_VIA_LOCAL_APPROVAL_PILOT_COMPLETE_NO_SAVE_NO_FULL_BOARD_DRC\n" length(hiAllVias()) axlCNSGetPhysical(parent "TOP" 'vias) axlDBControl('drcEnable)) close(f) t))
