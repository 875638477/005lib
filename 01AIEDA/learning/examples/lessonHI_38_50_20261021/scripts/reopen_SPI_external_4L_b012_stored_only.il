procedure(hiGroundPointCheckReadOnly(f id xy topConnected bottomConnected)
 let((graph shapes expected actual)
  graph=gConnectedObjects(gPin("U1" "23"))
  foreach(layer list("TOP" "BOTTOM")
   expected=if(equal(layer "TOP") then topConnected else bottomConnected)
   shapes=setof(s axlDBGetShapes(strcat("ETCH/" layer)) s->fill && s->net && equal(s->net->name "GND") && !s->shapeIsBoundary && axlGeoPointInShape(xy s t))
   unless(length(shapes)==1 error("Ground stitch point must be inside exactly one actual filled GND shape on each layer, layer=%L shapes=%L\n" layer shapes))
   unless(car(shapes)->shapeBoundary error("Ground stitch point must be in application dynamic copper, not static quiet island\n"))
   actual=if(member(car(shapes) graph) then t else nil)
   fprintf(f "HI_GROUND_POINT_CHECK id=%L layer=%L xy=%L bbox=%L globalPin=U1.23 expectedConnected=%L actualConnected=%L shapeAttrs=%L\n" id layer xy car(shapes)->bBox expected actual car(shapes)->??)
   unless(equal(expected actual) error("Application ground shape connectivity does not match intended stitch pre/post condition\n")))
  t))

; Instrument exact unchanged all-on-plus-batch DRC request and result.
procedure(hiStoredReadback()
 let((f)
 f=outfile("D:/001DIY/005lib/01AIEDA/learning/examples/lessonHI_38_50_20261021/logs/reopen_SPI_external_4L_b012_stored_only/hi_reopen_endpoint_proofs.txt")
 hiRegistry=nil hiNodeDefinitions=list(list("HI_4L_SPI_SCK_1_V1" "SPI_SCK" "TOP" list(31.0 29.95) "via") list("HI_4L_SPI_SCK_1_R1" "SPI_SCK" "TOP" list(32.0252 31.0) "point") list("HI_4L_SPI_SCK_1_R2" "SPI_SCK" "BOTTOM" list(31.0 29.95) "point") list("HI_4L_SPI_MISO_1_V1" "SPI_MISO" "TOP" list(31.65 28.2) "via") list("HI_4L_SPI_MISO_1_V2" "SPI_MISO" "TOP" list(15.7 29.3) "via") list("HI_4L_SPI_MISO_1_R1" "SPI_MISO" "TOP" list(32.0252 29.0) "point") list("HI_4L_SPI_MISO_1_R2" "SPI_MISO" "BOTTOM" list(31.65 28.2) "point") list("HI_4L_SPI_MISO_1_R3" "SPI_MISO" "TOP" list(15.7 29.3) "point") list("HI_4L_SPI_MOSI_1_V1" "SPI_MOSI" "TOP" list(32.7 26.25) "via") list("HI_4L_SPI_MOSI_1_V2" "SPI_MOSI" "TOP" list(12.65 28.65) "via") list("HI_4L_SPI_MOSI_1_R1" "SPI_MOSI" "TOP" list(32.0252 27.0) "point") list("HI_4L_SPI_MOSI_1_R2" "SPI_MOSI" "BOTTOM" list(32.7 26.25) "point") list("HI_4L_SPI_MOSI_1_R3" "SPI_MOSI" "TOP" list(12.65 28.65) "point") list("HI_4L_SPI_NSS_1_V1" "SPI_NSS" "TOP" list(29.8 32.3) "via") list("HI_4L_SPI_NSS_1_R1" "SPI_NSS" "TOP" list(31.2236 33.02) "point") list("HI_4L_SPI_NSS_1_R2" "SPI_NSS" "BOTTOM" list(29.8 32.3) "point") list("SPI4_RETURN_1" "GND" "TOP" list(30.95 29.0) "via") list("SPI4_RETURN_2" "GND" "TOP" list(15.1 28.55) "via") list("SPI4_RETURN_3" "GND" "TOP" list(12.2 27.8) "via") list("SPI4_RETURN_4" "GND" "TOP" list(29.2 33.05) "via"))
 hiBindExistingVia(f "HI_4L_SPI_SCK_1_V1" "SPI_SCK" list(31.0 29.95) "L28_VIA030_C060")
 hiBindExistingVia(f "HI_4L_SPI_MISO_1_V1" "SPI_MISO" list(31.65 28.2) "L28_VIA030_C060")
 hiBindExistingVia(f "HI_4L_SPI_MISO_1_V2" "SPI_MISO" list(15.7 29.3) "L28_VIA030_C060")
 hiBindExistingVia(f "HI_4L_SPI_MOSI_1_V1" "SPI_MOSI" list(32.7 26.25) "L28_VIA030_C060")
 hiBindExistingVia(f "HI_4L_SPI_MOSI_1_V2" "SPI_MOSI" list(12.65 28.65) "L28_VIA030_C060")
 hiBindExistingVia(f "HI_4L_SPI_NSS_1_V1" "SPI_NSS" list(29.8 32.3) "L28_VIA030_C060")
 hiBindExistingVia(f "SPI4_RETURN_1" "GND" list(30.95 29.0) "L28_VIA030_C060")
 hiBindExistingVia(f "SPI4_RETURN_2" "GND" list(15.1 28.55) "L28_VIA030_C060")
 hiBindExistingVia(f "SPI4_RETURN_3" "GND" list(12.2 27.8) "L28_VIA030_C060")
 hiBindExistingVia(f "SPI4_RETURN_4" "GND" list(29.2 33.05) "L28_VIA030_C060")
 hiProof(f "R21.2" "J6.2" t)
 hiProof(f "R22.2" "J6.3" t)
 hiProof(f "R24.2" "J6.4" t)
 hiProof(f "R23.2" "J6.5" t)
 hiProof(f "SPI4_RETURN_1" "U1.23" t)
 hiProof(f "SPI4_RETURN_2" "U1.23" t)
 hiProof(f "SPI4_RETURN_3" "U1.23" t)
 hiProof(f "SPI4_RETURN_4" "U1.23" t)
 fprintf(f "HI_REOPEN_ALL_ENDPOINTS_COMPLETE_STORED_STATE_ONLY_NO_DRC_RECOMPUTE\n") close(f)
 f=outfile("D:/001DIY/005lib/01AIEDA/learning/examples/lessonHI_38_50_20261021/logs/reopen_SPI_external_4L_b012_stored_only/hi_readback_scope.txt")
 fprintf(f "READBACK_SCOPE=FRESH_STORED_STATE_GEOMETRY_CONNECTIVITY_ONLY\nFULL_DRC_RECOMPUTE=NOT_REQUESTED_IN_THIS_READBACK\nFINAL_WHOLE_BOARD_DRC_PENDING=t\nHSE_NEGATIVE_NOT_REPEATED_HERE_BUILD_EVIDENCE_REMAINS\nDRC_ENABLE=%L\nSTORED_DRC_COUNT=%d\nPHYSICAL_MODES=%L\nSPACING_MODES=%L\nELECTRICAL_MODES=%L\n" axlDBControl('drcEnable) length(axlDBGetDesign()->drcs) axlCNSPhysicalModeGet('all) axlCNSSpacingModeGet('all) axlCNSEcsetModeGet('all)) close(f) t))
