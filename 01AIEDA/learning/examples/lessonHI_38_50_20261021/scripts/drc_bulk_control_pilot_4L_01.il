procedure(hiDrcControlPilot()
 let((f mark ret initial errors)
  f=outfile("D:/001DIY/005lib/01AIEDA/learning/examples/lessonHI_38_50_20261021/logs/drc_bulk_control_pilot_4L_01/hi_drc_bulk_control_pilot.txt")
  initial=axlDBControl('drcEnable)
  fprintf(f "INITIAL_DRC_ENABLED=%L\n" initial)
  unless(initial error("Pilot expects source DRC enabled\n"))
  mark=axlDBTransactionStart()
  unless(mark error("Cannot begin controlled batch pilot transaction\n"))
  ret=errset(
   unwindProtect(
    progn(
     axlDBControl('drcEnable nil)
     fprintf(f "DURING_ASSEMBLY_DRC_ENABLED=%L\n" axlDBControl('drcEnable))
     when(axlDBControl('drcEnable) error("Online DRC was not temporarily disabled\n"))
     hiVia(f "HI_PILOT_V3VIA" "V3V3" list(50.0 48.0) "L28_VIA030_C060")
     hiRoute(f "HI_PILOT_INTENTIONALLY_TOO_THIN" "V3V3" "TOP" list(50.0:48.0 52.0:48.0) list(0.10))
     error("HI_EXPECTED_FORCED_ERROR_TO_VERIFY_UNWIND_RESTORE\n"))
    progn(
     axlDBControl('drcEnable t)
     fprintf(f "UNWIND_AFTER_FORCED_ERROR_DRC_ENABLED=%L\n" axlDBControl('drcEnable))))
   t)
  fprintf(f "FORCED_ERROR_ERRSET_RESULT=%L EXPECTED_NIL=t\n" ret)
  when(ret error("Controlled failure did not trigger\n"))
  unless(axlDBControl('drcEnable) error("Unwind cleanup failed to restore online DRC\n"))
  axlDBRefreshId(nil) axlShapeDynamicUpdate(nil t)
  axlDRCUpdate(t) f29DumpDRC(f "AFTER_ENABLE_FULL_CHECK_ACTUAL_BAD_COPPER")
  errors=length(axlDBGetDesign()->drcs)
  unless(errors>0 error("Final full checks failed to detect actual too-thin copper\n"))
  unless(axlDBTransactionRollback(mark) error("Cannot roll back controlled pilot\n"))
  axlDBControl('drcEnable t)
  axlDBRefreshId(nil) axlShapeDynamicUpdate(nil t)
  axlDRCUpdate(t) f29DumpDRC(f "ROLLED_BACK_BASELINE_FULL_CHECK")
  unless(length(axlDBGetDesign()->drcs)==0 && axlDBControl('drcEnable) error("Pilot rollback / enabled full DRC did not restore clean baseline\n"))
  fprintf(f "HI_DRC_BULK_CONTROL_PILOT_COMPLETE_NO_SAVE badCopperDetected=%d finalDRCEnabled=%L\n" errors axlDBControl('drcEnable))
  close(f) t))
