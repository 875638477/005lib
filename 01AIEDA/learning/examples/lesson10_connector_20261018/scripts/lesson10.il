; Lesson10: isolated real connector, no user project/public library changes.
procedure(l10Setup(lib)
 axlDBChangeDesignUnits("millimeters" 3)
 unless(axlDBChangeDesignExtents(list(-50:-50 50:50)) error("Extents failed\n"))
 axlSetVariable("padpath" list(lib))
 axlSetVariable("psmpath" list(lib))
)
procedure(l10CreatePackage(base out)
 let((f style pintext result p c bound x layer cases)
 unless(equal(axlCurrentDesign() "l10_gct_usb4105_gf_a_12land") error("Wrong drawing\n"))
 unless(equal(axlDesignType(t) "PACKAGE") error("Wrong type\n"))
 l10Setup(strcat(base "/library"))
 f=outfile(strcat(out "/create.txt"))
 fprintf(f "L10_PACKAGE START\n")
 style=make_axlTextOrientation(?textBlock "2" ?rotation 0 ?mirrored nil ?justify "center")
 cases=list(
list("l10_usb4105_smd060x115" -3.200:3.680 "A1_B12")
list("l10_usb4105_smd060x115" -2.400:3.680 "A4_B9")
list("l10_usb4105_smd030x115" -1.750:3.680 "B8")
list("l10_usb4105_smd030x115" -1.250:3.680 "A5")
list("l10_usb4105_smd030x115" -0.750:3.680 "B7")
list("l10_usb4105_smd030x115" -0.250:3.680 "A6")
list("l10_usb4105_smd030x115" 0.250:3.680 "A7")
list("l10_usb4105_smd030x115" 0.750:3.680 "B6")
list("l10_usb4105_smd030x115" 1.250:3.680 "A8")
list("l10_usb4105_smd030x115" 1.750:3.680 "B5")
list("l10_usb4105_smd060x115" 2.400:3.680 "B4_A9")
list("l10_usb4105_smd060x115" 3.200:3.680 "B1_A12")
list("l10_usb4105_slot060x170" -4.320:3.105 "SH1")
list("l10_usb4105_slot060x170" 4.320:3.105 "SH2")
list("l10_usb4105_slot060x140" -4.320:-1.075 "SH3")
list("l10_usb4105_slot060x140" 4.320:-1.075 "SH4")
list("l10_usb4105_npth065" -2.890:2.605 nil)
list("l10_usb4105_npth065" 2.890:2.605 nil)
 )
 foreach(c cases
  p=axlLoadPadstack(car(c))
  unless(p error("Pad load failed\n"))
  pintext=if(caddr(c) then make_axlPinText(?number caddr(c) ?offset 0:0 ?text style) else nil)
  result=axlDBCreatePin(p cadr(c) pintext 0.0)
  unless(result error("Pin create failed\n"))
  fprintf(f "PIN number=%L xy=%L mechanical=%L drc=%L\n" car(result)->number car(result)->xy car(result)->isMech cadr(result))
 )
 foreach(layer list("PACKAGE GEOMETRY/USER_BOARD_EDGE" "PACKAGE GEOMETRY/USER_MATING_TOP" "PACKAGE GEOMETRY/USER_MATING_BOTTOM")
  unless(axlLayerCreateNonConductor(layer) error("Create helper layer failed\n")))
 unless(axlDBCreateLine(list(-4.47:-3.675 4.47:-3.675 4.47:3.675 -4.47:3.675 -4.47:-3.675) 0.05 "PACKAGE GEOMETRY/ASSEMBLY_TOP" nil nil) error("Assembly failed\n"))
 ; Silk avoids rear SMT row and solder openings; no front line outside PCB.
 foreach(x list(-5.12 5.12)
  unless(axlDBCreateLine(list(x:-3.3 x:2.0) 0.12 "PACKAGE GEOMETRY/SILKSCREEN_TOP" nil nil) error("Silk failed\n")))
 unless(axlDBCreateLine(list(-4.8:4.5 -4.5:4.8 -4.2:4.5) 0.1 "PACKAGE GEOMETRY/SILKSCREEN_TOP" nil nil) error("Pin marker failed\n"))
 result=axlDBCreateRectangle(list(-5.12:-4.0 5.12:4.555) t "PACKAGE GEOMETRY/PLACE_BOUND_TOP" nil nil)
 unless(result error("Placebound failed\n"))
 bound=car(result)
 unless(axlDBAddProp(list(bound) list("PACKAGE_HEIGHT_MAX" "3.46 MM")) error("Height failed\n"))
 unless(axlDBCreateLine(list(-6:-3.675 6:-3.675) 0.05 "PACKAGE GEOMETRY/USER_BOARD_EDGE" nil nil) error("Boardedge helper failed\n"))
 unless(axlDBCreateLine(list(-6:-15.675 6:-15.675 6:-3.675 -6:-3.675 -6:-15.675) 0.05 "PACKAGE GEOMETRY/USER_MATING_TOP" nil nil) error("Mating helper failed\n"))
 foreach(x list(-2.89 2.89)
  unless(axlDBCreateRectangle(list((x-0.425):2.180 (x+0.425):3.030) t "ROUTE KEEPOUT/ALL" nil nil) error("NPTH route keepout failed\n")))
 foreach(layer list("REF DES/SILKSCREEN_TOP" "REF DES/ASSEMBLY_TOP")
  unless(axlDBCreateText("J*" 0:0 style layer nil) error("Refdes failed\n")))
 unless(axlDBCreateText("VALUE" 0:0 style "COMPONENT VALUE/ASSEMBLY_TOP" nil) error("Value failed\n"))
 unless(axlSaveDesign(?design strcat(base "/library/l10_gct_usb4105_gf_a_12land.dra") ?noMru t ?noConfirm t) error("Save failed\n"))
 unless(axlCompileSymbol(?symbol strcat(base "/library/l10_gct_usb4105_gf_a_12land")) error("Compile failed\n"))
 fprintf(f "L10_PACKAGE COMPLETE\n")
 close(f)
 t
))
procedure(l10CreateBoard(base out)
 let((f c result xs)
 unless(equal(axlCurrentDesign() "lesson10_connector") error("Wrong board\n"))
 l10Setup(strcat(base "/library"))
 foreach(xs axlXSectionGet(nil 'all)
  when(equal(xs->layerType "CONDUCTOR")
   unless(axlXSectionSet(xs axlXSectionModify(?thickness 0.035)) error("Copper thickness failed\n")))
  when(equal(xs->layerType "DIELECTRIC")
   unless(axlXSectionSet(xs axlXSectionModify(?thickness 0.730)) error("Dielectric thickness failed\n"))))
 f=outfile(strcat(out "/create.txt"))
 fprintf(f "L10_BOARD START\n")
 foreach(c list(list(-15:0 nil 0.0) list(26.325:12 nil 90.0) list(15:0 t 0.0))
  result=axlDBCreateSymbol(list("l10_gct_usb4105_gf_a_12land" "PACKAGE") car(c) cadr(c) caddr(c))
  unless(result error("PSM place failed\n"))
  fprintf(f "placed=%L xy=%L rotation=%L mirror=%L\n" car(result)->name car(result)->xy car(result)->rotation car(result)->isMirrored))
 unless(axlDBCreateLine(list(-30:-3.675 30:-3.675 30:30 -30:30 -30:-3.675) 0.05 "BOARD GEOMETRY/OUTLINE" nil nil) error("Board outline failed\n"))
 unless(axlSaveDesign(?design strcat(base "/lesson10_connector.brd") ?noMru t ?noConfirm t) error("Board save failed\n"))
 fprintf(f "L10_BOARD COMPLETE\n")
 close(f)
 t
))

procedure(l10Read(out)
 let((f pf gf sf pins p ps poly layer sym obj geom pad box x1 y1 x2 y2 segments seg)
 f=outfile(strcat(out "/summary.txt"))
 pf=outfile(strcat(out "/pins.tsv"))
 gf=outfile(strcat(out "/geometry.tsv"))
 sf=outfile(strcat(out "/symbols.tsv"))
 unless(f && pf && gf && sf error("Readback output failed\n"))
 fprintf(f "L10_READ START\ndesign=%L type=%L units=%L drcs=%d drcState=%L\n" axlCurrentDesign() axlDesignType(t) axlDBGetDesignUnits() length(axlDBGetDesign()->drcs) axlDBGetDesign()->drcState)
 fprintf(pf "number\tpadstack\tx\ty\trelx\trely\trotation\tmirrored\tmechanical\thole_type\tplating\tdrill_x\tdrill_y\tdrill_diameter\tlayer\tfigure\tw\th\tpoly_bbox\tvertices\n")
 fprintf(gf "type\tlayer\tx1\ty1\tx2\ty2\ttext\tx\ty\trotation\tmirrored\tfilled\tprops\n")
 fprintf(sf "x\ty\trotation\tmirrored\tname\tpins\n")
 pins=axlDBGetDesign()->pins
 foreach(sym axlDBGetDesign()->symbols
  pins=append(pins sym->pins)
  fprintf(sf "%L\t%L\t%L\t%L\t%L\t%d\n" car(sym->xy) cadr(sym->xy) sym->rotation sym->isMirrored sym->name length(sym->pins)))
 foreach(p pins
  ps=p->definition
  foreach(layer list("ETCH/TOP" "ETCH/BOTTOM" "PIN/SOLDERMASK_TOP" "PIN/SOLDERMASK_BOTTOM" "PIN/PASTEMASK_TOP" "PIN/PASTEMASK_BOTTOM")
   pad=axlDBGetPad(p layer "REGULAR")
   poly=car(axlPolyFromDB(p ?layer layer ?padType 'REGULAR))
   box=if(pad then pad->bBox else nil)
   fprintf(pf "%L\t%L\t%L\t%L\t%L\t%L\t%L\t%L\t%L\t%L\t%L\t%L\t%L\t%L\t%L\t%L\t%L\t%L\t%L\t%L\n"
    p->number p->name car(p->xy) cadr(p->xy) car(p->relxy) cadr(p->relxy)
    p->rotation p->isMirrored p->isMech ps->holeType ps->plating ps->drillSizeWidth ps->drillSizeHeight ps->drillDiameter layer
    if(pad then pad->figureName else nil)
    if(box then car(cadr(box))-car(car(box)) else nil)
    if(box then cadr(cadr(box))-cadr(car(box)) else nil)
    if(poly then poly->bBox else nil) if(poly then poly->vertices else nil))))
 geom=axlExtractMap("C:/Program0/Cadence/SPB172/share/pcb/text/views/fgeo_bv.txt" nil)
 foreach(obj geom
  box=obj->bBox
  when(box
   fprintf(gf "%L\t%L\t%L\t%L\t%L\t%L\t%L\t%L\t%L\t%L\t%L\t%L\t%L\n"
    obj->objType obj->layer car(car(box)) cadr(car(box)) car(cadr(box)) cadr(cadr(box))
    if(equal(obj->objType "text") then obj->text else nil)
    if(equal(obj->objType "text") then car(obj->xy) else nil)
    if(equal(obj->objType "text") then cadr(obj->xy) else nil)
    if(equal(obj->objType "text") then obj->rotation else nil)
    if(equal(obj->objType "text") then obj->isMirrored else nil)
    if(equal(obj->objType "shape") then obj->fill else nil)
    axlDBGetProperties(obj nil))))
 foreach(obj axlXSectionGet(nil 'all) fprintf(f "STACK %L %L %L\n" obj->name obj->layerType obj->thickness))
 fprintf(f "PIN_COUNT=%d\nL10_READ COMPLETE\n" length(pins))
 foreach(obj list(f pf gf sf) close(obj))
 t
))
