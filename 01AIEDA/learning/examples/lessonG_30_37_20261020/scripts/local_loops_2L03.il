procedure(gEscapeRegion(f)
 let((region shape tbl)
  fprintf(f "REGION_LAYER_SUBCLASSES=%L\n" axlGetParam("paramLayerGroup:CONSTRAINT REGION")->groupMembers)
  unless(axlIsLayer("CONSTRAINT REGION/TOP") error("Actual TOP constraint subclass unavailable\n"))
  f29Must(axlCNSCreate('spacing "G31_PIN_ESCAPE" "S_POWER_030") "Local escape spacing CSet")
  foreach(k list('smdpin_line 'line_line)
   f29Must(axlCNSSetSpacing("G31_PIN_ESCAPE" nil k "0.20 MM") "Only local line escape spacing"))
  region=axlRegionCreate("G31_U1_ESCAPE")
  unless(region error("Native region unavailable\n"))
  foreach(box list(list(34.2:23.5 36.5:25.5) list(41.5:21.2 43.5:23.5) list(43.5:28.5 45.8:30.5))
   shape=car(axlDBCreateRectangle(box nil "CONSTRAINT REGION/TOP"))
   unless(shape && axlRegionAdd(region shape) error("Native region rectangle failed\n"))
   fprintf(f "ESCAPE_REGION_RECT=%L\n" shape->??))
  tbl=axlCnsClassTableCreate("NC_POWER_LV_S" nil region 'spacing "G31_PIN_ESCAPE")
  unless(tbl error("Native region-class spacing assignment failed\n"))
  fprintf(f "ESCAPE_REGION=%L\nESCAPE_CLASS_TABLE=%L\n" region->?? tbl->??)
  axlCNSMapUpdate()
  t))

procedure(gLocalLoops(out board lib refLayer)
 let((f result)
  f=outfile(strcat(out "/local_loops.txt"))
  fprintf(f "TWO_LAYER_NO_SPACING_EXCEPTION_NEEDED\n")
  gRouteNative("V3V3" list(35.20:24.25 34.95:24.25 34.55:23.85 33.4:23.7) list(0.25 0.25 0.60) "ETCH/TOP" f "C13_VDD")
  gRouteNative("GND" list(35.20:24.75 34.95:24.75 34.55:25.15 33.4:25.2748 32.45:25.2748) list(0.25 0.25 0.60 0.60) "ETCH/TOP" f "C13_GND")
  gRouteNative("V3V3" list(42.75:22.20 42.75:21.95 43.15:21.55 43.9:20.8 43.9:20.3) list(0.25 0.25 0.60 0.60) "ETCH/TOP" f "C14_VDD")
  gRouteNative("GND" list(42.25:22.20 42.25:21.95 41.85:21.55 42.3252:21.0748 42.3252:20.3 42.3252:19.35) list(0.25 0.25 0.60 0.60 0.60) "ETCH/TOP" f "C14_GND")
  gRouteNative("V3V3" list(44.80:29.75 45.05:29.75 45.45:30.15 46.5:30.3) list(0.25 0.25 0.60) "ETCH/TOP" f "C15_VDD")
  gRouteNative("GND" list(44.80:29.25 45.05:29.25 45.45:28.85 46.5:28.7252 47.45:28.7252) list(0.25 0.25 0.60 0.60) "ETCH/TOP" f "C15_GND")
  foreach(pt list(32.45:25.2748 42.3252:19.35 47.45:28.7252)
   result=axlDBCreateVia("L28_VIA030_C060" pt "GND" nil 0.0 nil)
   fprintf(f "LOCAL_GND_VIA %L %L\n" pt result)
   unless(result error("Local ground via failed\n")))
  axlDBRefreshId(nil)
  axlDRCUpdate(t) f29DumpDRC(f "LOOPS_BEFORE_REFERENCE")
  gReference(refLayer f)
  axlDRCUpdate(t) f29DumpDRC(f "LOOPS_WITH_REFERENCE")
  gConnectivityProof(f "U1" "24" "C13" "1" nil)
  gConnectivityProof(f "U1" "23" "C13" "2" refLayer)
  gConnectivityProof(f "U1" "36" "C14" "1" nil)
  gConnectivityProof(f "U1" "35" "C14" "2" refLayer)
  gConnectivityProof(f "U1" "48" "C15" "1" nil)
  gConnectivityProof(f "U1" "47" "C15" "2" refLayer)
  unless(axlSaveDesign(?design board ?noMru t ?noConfirm t) error("Local loop save failed\n"))
  fprintf(f "G_LOCAL_LOOPS_COMPLETE\n") close(f)
  gSnapshot(out lib)
  t))
