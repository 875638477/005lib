procedure(gLocalLoops(out board lib refLayer)
 let((f result)
  f=outfile(strcat(out "/local_loops.txt"))
  gRouteNative("V3V3" list(35.15:24.25 34.95:24.25 34.55:23.85 33.4:23.7) list(0.25 0.25 0.60) "ETCH/TOP" f "C13_VDD")
  gRouteNative("GND" list(35.15:24.75 34.95:24.75 34.55:25.15 33.4:25.2748 32.45:25.2748) list(0.25 0.25 0.60 0.60) "ETCH/TOP" f "C13_GND")
  gRouteNative("V3V3" list(42.75:22.15 42.75:21.95 43.15:21.55 43.9:20.8 43.9:20.3) list(0.25 0.25 0.60 0.60) "ETCH/TOP" f "C14_VDD")
  gRouteNative("GND" list(42.25:22.15 42.25:21.95 41.85:21.55 42.3252:21.0748 42.3252:20.3 42.3252:19.35) list(0.25 0.25 0.60 0.60 0.60) "ETCH/TOP" f "C14_GND")
  gRouteNative("V3V3" list(44.85:29.75 45.05:29.75 45.45:30.15 46.5:30.3) list(0.25 0.25 0.60) "ETCH/TOP" f "C15_VDD")
  gRouteNative("GND" list(44.85:29.25 45.05:29.25 45.45:28.85 46.5:28.7252 47.45:28.7252) list(0.25 0.25 0.60 0.60) "ETCH/TOP" f "C15_GND")
  foreach(pt list(32.45:25.2748 42.3252:19.35 47.45:28.7252)
   result=axlDBCreateVia("L28_VIA030_C060" pt "GND" nil 0.0 nil)
   fprintf(f "LOCAL_GND_VIA %L %L\n" pt result)
   unless(result error("Local ground via failed\n")))
  axlDBRefreshId(nil)
  axlDRCUpdate(t) f29DumpDRC(f "LOOPS_BEFORE_REFERENCE")
  gReference(refLayer f)
  axlDRCUpdate(t) f29DumpDRC(f "LOOPS_WITH_REFERENCE")
  gConnectivityProof(f "U1" "24" "C13" "1" nil)
  gConnectivityProof(f "U1" "23" "C13" "2" refLayer)
  gConnectivityProof(f "U1" "36" "C14" "1" nil)
  gConnectivityProof(f "U1" "35" "C14" "2" refLayer)
  gConnectivityProof(f "U1" "48" "C15" "1" nil)
  gConnectivityProof(f "U1" "47" "C15" "2" refLayer)
  unless(axlSaveDesign(?design board ?noMru t ?noConfirm t) error("Local loop save failed\n"))
  fprintf(f "G_LOCAL_LOOPS_COMPLETE\n") close(f)
  gSnapshot(out lib)
  t))
