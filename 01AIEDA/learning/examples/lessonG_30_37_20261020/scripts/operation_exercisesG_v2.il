procedure(gPose(ref)
 let((s)
  s=gComponent(ref)->symbol
  list(s->xy s->rotation s->isMirrored)))
procedure(gPoseAll()
 mapcar(lambda((c) list(c->name gPose(c->name))) axlDBGetDesign()->components))
procedure(gOperationExercises(out)
 let((f mark before s target group members r x y)
  f=outfile(strcat(out "/operation_exercises.txt"))
  before=gPoseAll()
  mark=axlDBTransactionStart()
  unless(mark error("Cannot start placement exercise transaction\n"))
  fprintf(f "R30_BEFORE=%L\n" gPose("R30"))
  s=gComponent("R30")->symbol
  r=axlTransformObject(s ?move list(1.0 0.5))
  unless(r error("Native single symbol move failed\n"))
  fprintf(f "R30_MOVED=%L RESULT=%L\n" gPose("R30") r)
  s=gComponent("R30")->symbol
  r=axlTransformObject(s ?angle 90)
  unless(r error("Native single symbol rotation failed\n"))
  fprintf(f "R30_ROTATED=%L RESULT=%L\n" gPose("R30") r)
  target=car(gPose("R29"))
  s=gComponent("R30")->symbol
  r=axlTransformObject(s ?move list(0.0 cadr(target)-cadr(s->xy)))
  unless(r error("Native alignment move failed\n"))
  unless(equal(cadr(car(gPose("R30"))) cadr(target)) error("Alignment not applied\n"))
  fprintf(f "ORIGIN_Y_ALIGNED R30=%L R29=%L\n" gPose("R30") gPose("R29"))
  members=list(gComponent("C13")->symbol gComponent("C14")->symbol)
  group=axlDBCreateGroup("G_TEMP_MOVE_EXERCISE" "generic" members)
  unless(group error("Native generic group creation failed\n"))
  fprintf(f "GROUP_BEFORE=%L C13=%L C14=%L\n" group->?? gPose("C13") gPose("C14"))
  r=axlTransformObject(group ?move list(0.5 0.5) ?allOrNone t)
  fprintf(f "GROUP_TRANSFORM_RESULT=%L C13=%L C14=%L\n" r gPose("C13") gPose("C14"))
  fprintf(f "GENERIC_DIRECT_TRANSFORM_NOT_ASSUMED_MEMBER_MOVE\n")
  r=axlTransformObject(group->groupMembers ?move list(0.5 0.5) ?allOrNone t)
  axlDBRefreshId(nil)
  fprintf(f "GROUP_MEMBERS_BATCH_TRANSFORM=%L C13=%L C14=%L\n" r gPose("C13") gPose("C14"))
  unless(equal(car(gPose("C13")) list(33.9 24.0984)) && equal(car(gPose("C14")) list(44.5016 20.8))
   error("Native group-members batch move did not apply\n"))
  unless(axlDBTransactionRollback(mark) error("Native rollback failed\n"))
  unless(equal(before gPoseAll()) error("Placement exercise rollback not exact\n"))
  unless(!car(setof(x axlDBGetDesign()->groups equal(x->name "G_TEMP_MOVE_EXERCISE"))) error("Temporary exercise group leaked\n"))
  axlDRCUpdate(t)
  f29DumpDRC(f "EXERCISES_ROLLBACK")
  fprintf(f "ALL80_POSES_RESTORED_EXACTLY\nG_NATIVE_EXERCISES_COMPLETE\n")
  close(f) t))
