procedure(gTwoLayerRules(f)
 let((net c)
  unless(equal(axlSubclassRoute() list("TOP" "BOTTOM")) error("Two-layer profile on wrong layer variant\n"))
  foreach(k list('width_min 'neckwidth_min) f29Must(axlCNSSetPhysical("" nil k "0.2032 MM") "2L manufacturing default width"))
  f29Must(axlCNSSetPhysical("" nil 'necklength_max "1 MM") "2L default neck budget")
  f29Must(axlCNSSetPhysical("" nil 'vias "L28_VIA030_C060") "2L approved through via")
  foreach(c list("G2L_POWER_DEMO" "G2L_GND_DEMO")
   f29Must(axlCNSCreate('physical c nil) "2L independent physical CSet")
   foreach(v list(list('width_min "0.60 MM") list('neckwidth_min "0.25 MM") list('necklength_max "1 MM") list('vias "L28_VIA030_C060"))
    f29Must(axlCNSSetPhysical(c nil car(v) cadr(v)) "2L independent local-loop CSet")))
  f29Must(axlCNSCreate('spacing "G2L_POWER_GND_SPACING" nil) "2L power ground spacing CSet")
  foreach(k axlCNSGetSpacing(nil nil nil)
   unless(member(k list('bbvia_gap 'hole_via 'hole_thrupin 'hole_hole 'hole_shape 'hole_line))
    f29Must(axlCNSSetSpacing("G2L_POWER_GND_SPACING" nil k "0.20 MM") "2L power ground spacing")))
  foreach(row list(list("V3V3" "G2L_POWER_DEMO") list("GND" "G2L_GND_DEMO"))
   net=axlDBFindByName('net car(row))
   axlDBAddProp(list(net) list(list("PHYSICAL_CONSTRAINT_SET" cadr(row)) list("SPACING_CONSTRAINT_SET" "G2L_POWER_GND_SPACING")))
   unless(equal(cadr(assoc('PHYSICAL_CONSTRAINT_SET axlDBGetProperties(net))) cadr(row)) error("2L net CSet override missing\n")))
  foreach(k axlCNSGetSpacing(nil nil nil)
   unless(member(k list('bbvia_gap 'hole_via 'hole_thrupin 'hole_hole 'hole_shape 'hole_line))
    f29Must(axlCNSSetSpacing("" nil k "0.16 MM") "2L independent spacing default")))
  axlCNSPhysicalModeSet('width_min 'on)
  axlCNSPhysicalModeSet('vias 'on)
  axlCNSSpacingModeSet('all 'on)
  fprintf(f "TWO_LAYER_LOCAL_PROFILE_CREATED mapUpdate=%L\n" axlCNSMapUpdate())
  t))
procedure(gReconcile(plan board out lib twoLayer)
 let((f s target delta ang result)
  f=outfile(strcat(out "/reconcile.txt"))
  foreach(row plan
   s=gComponent(car(row))->symbol
   unless(s error("Reconcile expects all80 already placed\n"))
   target=list(cadr(row) caddr(row))
   unless(equal(s->xy target)
    delta=list(car(target)-car(s->xy) cadr(target)-cadr(s->xy))
    fprintf(f "BEFORE_MOVE %L %L %L\n" car(row) s->xy s->rotation)
    result=axlTransformObject(s ?move delta)
    unless(result error("Approved placement adjustment failed\n"))
    axlDBRefreshId(nil)
    s=gComponent(car(row))->symbol
    fprintf(f "AFTER_MOVE %L %L %L\n" car(row) s->xy s->rotation))
   ang=cadddr(row)-s->rotation
   unless(equal(ang 0.0)
    fprintf(f "BEFORE_ROTATION %L %L %L\n" car(row) s->xy s->rotation)
    result=axlTransformObject(s ?angle ang)
    unless(result error("Approved rotation adjustment failed\n"))
    axlDBRefreshId(nil)
    s=gComponent(car(row))->symbol
    fprintf(f "AFTER_ROTATION %L %L %L\n" car(row) s->xy s->rotation))
   unless(equal(s->xy target) && equal(s->rotation cadddr(row)) error("Actual pose not equal approved plan\n")))
  when(twoLayer gTwoLayerRules(f))
  axlDRCUpdate(t) f29DumpDRC(f "RECONCILED")
  unless(axlSaveDesign(?design board ?noMru t ?noConfirm t) error("Reconciled board save failed\n"))
  fprintf(f "G_RECONCILE_COMPLETE\n") close(f)
  gSnapshot(out lib)
  t))
