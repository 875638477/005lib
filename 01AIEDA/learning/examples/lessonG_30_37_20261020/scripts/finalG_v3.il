procedure(gGFinalProof(out refLayer)
 let((f r poly v c s)
  f=outfile(strcat(out "/g_final_connectivity_constraints.txt"))
  foreach(row list(list("24" "C13" "1" nil) list("23" "C13" "2" refLayer) list("36" "C14" "1" nil) list("35" "C14" "2" refLayer) list("48" "C15" "1" nil) list("47" "C15" "2" refLayer))
   gConnectivityProof(f "U1" car(row) cadr(row) caddr(row) cadddr(row)))
  gConnectivityProof(f "C15" "1" "C16" "1" nil)
  gConnectivityProof(f "C15" "2" "C16" "2" refLayer)
  fprintf(f "REGIONS=%L\n" axlDBGetDesign()->region)
  foreach(r axlDBGetDesign()->region
   fprintf(f "REGION %L\n" r->??)
   foreach(s r->groupMembers
    poly=car(axlPolyFromDB(s))
    fprintf(f "REGION_SHAPE %L vertices=%L\n" s->?? if(poly then poly->vertices else nil))))
  foreach(c axlCnsClassTableFind('netclass)
   fprintf(f "TABLE class1=%L class2=%L region=%L physical=%L spacing=%L attrs=%L\n"
    if(c->netclass1 then c->netclass1->name else nil) if(c->netclass2 then c->netclass2->name else nil)
    if(c->region then c->region->name else nil) c->physical c->spacing c->??))
  foreach(c list("P_POWER_060" "P_GND_PLANE" "G2L_POWER_DEMO" "G2L_GND_DEMO" "G31_POWER_ESCAPE" "G31_GND_ESCAPE")
   when(member(c axlCnsList('physical))
    foreach(k list('width_min 'neckwidth_min 'necklength_max 'vias 'allow_etch)
     fprintf(f "PHYSICAL_CSET %L %L %L\n" c k axlCNSGetPhysical(c "TOP" k)))))
  fprintf(f "DYNAMIC_OOD=%L\n" axlDBDynamicShapes(nil))
  f29DumpDRC(f "G_FINAL")
  fprintf(f "G_FINAL_NATIVE_PROOF_COMPLETE\n")
  close(f) t))
procedure(gBulk(out board lib refLayer)
 let((f)
  f=outfile(strcat(out "/bulk_branches.txt"))
  gRouteNative("V3V3" list(49.5:30.3 46.5:30.3) list(0.60) "ETCH/TOP" f "C16_BULK_V3V3")
  gRouteNative("GND" list(49.5:28.268 48.4:28.268 47.9428:28.7252 47.45:28.7252) list(0.60 0.60 0.60) "ETCH/TOP" f "C16_BULK_GND")
  axlDRCUpdate(t) f29DumpDRC(f "BULK")
  unless(length(axlDBGetDesign()->drcs)==0 error("Bulk branches introduce DRC\n"))
  gConnectivityProof(f "C15" "1" "C16" "1" nil)
  gConnectivityProof(f "C15" "2" "C16" "2" refLayer)
  unless(axlSaveDesign(?design board ?noMru t ?noConfirm t) error("Bulk final save failed\n"))
  fprintf(f "G_BULK_COMPLETE\n") close(f)
  gSnapshot(out lib) gGFinalProof(out refLayer)
  t))
