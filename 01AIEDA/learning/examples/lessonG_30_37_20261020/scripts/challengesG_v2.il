procedure(gRuleChallenges(out)
 let((f mark expected outsideSpacing outsideNeck)
  f=outfile(strcat(out "/local_rule_challenges.txt"))
  axlDRCUpdate(t) axlDBRefreshId(nil) f29DumpDRC(f "BASELINE")
  unless(length(axlDBGetDesign()->drcs)==0 error("Rule challenge requires clean baseline\n"))
  when(length(axlSubclassRoute())==4
   foreach(k list('smdpin_line 'line_line) f29Must(axlCNSSetSpacing("G31_PIN_ESCAPE" nil k "0.30 MM") "Challenge local spacing stricter"))
   axlDRCUpdate(t) axlDBRefreshId(nil) f29DumpDRC(f "LOCAL_SPACING_STRICT_030")
   unless(length(axlDBGetDesign()->drcs)>0 error("Region spacing challenge did not trigger actual DRC\n"))
   foreach(k list('smdpin_line 'line_line) f29Must(axlCNSSetSpacing("G31_PIN_ESCAPE" nil k "0.20 MM") "Restore local escape spacing"))
   axlDRCUpdate(t) axlDBRefreshId(nil)
   unless(length(axlDBGetDesign()->drcs)==0 error("Spacing restore not clean\n")))
  foreach(c list("G31_POWER_ESCAPE" "G31_GND_ESCAPE") f29Must(axlCNSSetPhysical(c nil 'necklength_max "1 MM") "Challenge local neck 1mm"))
  axlDRCUpdate(t) axlDBRefreshId(nil) f29DumpDRC(f "LOCAL_NECK_STRICT_1MM")
  unless(length(axlDBGetDesign()->drcs)>0 error("Local physical region did not govern actual neck DRC\n"))
  foreach(c list("G31_POWER_ESCAPE" "G31_GND_ESCAPE") f29Must(axlCNSSetPhysical(c nil 'necklength_max "1.4 MM") "Restore local neck 1.4mm"))
  axlDRCUpdate(t) axlDBRefreshId(nil)
  unless(length(axlDBGetDesign()->drcs)==0 error("Neck restore not clean\n"))
  mark=axlDBTransactionStart()
  unless(mark error("Cannot start outside-rule challenge transaction\n"))
  foreach(row list(list(40.0:50.0 "V3V3") list(45.0:50.0 "V3V3") list(40.0:50.75 "GND") list(45.0:50.75 "GND"))
   unless(axlDBCreateVia("L28_VIA030_C060" car(row) cadr(row) nil 0.0 nil) error("Outside coupon via failed\n")))
  gRouteNative("V3V3" list(40.0:50.0 41.2:50.0 45.0:50.0) list(0.25 0.60) "ETCH/TOP" f "OUTSIDE_POWER_NECK")
  gRouteNative("GND" list(40.0:50.75 45.0:50.75) list(0.60) "ETCH/TOP" f "OUTSIDE_GND_SPACE")
  axlShapeDynamicUpdate(nil nil)
  axlDRCUpdate(t) axlDBRefreshId(nil) f29DumpDRC(f "OUTSIDE_REGION_GLOBAL_RULES")
  outsideSpacing=setof(d axlDBGetDesign()->drcs equal(d->name "Line to Line Spacing"))
  outsideNeck=setof(d axlDBGetDesign()->drcs equal(d->name "Maximum Neck Length"))
  fprintf(f "OUTSIDE_LINE_SPACING_COUNT=%d OUTSIDE_MAX_NECK_COUNT=%d\n" length(outsideSpacing) length(outsideNeck))
  unless(outsideSpacing && outsideNeck error("Global outside region rules not independently demonstrated\n"))
  unless(axlDBTransactionRollback(mark) error("Cannot rollback outside coupon\n"))
  axlDBRefreshId(nil)
  axlShapeDynamicUpdate(nil nil)
  axlDRCUpdate(t) axlDBRefreshId(nil) f29DumpDRC(f "CHALLENGES_RESTORED")
  unless(length(axlDBGetDesign()->drcs)==0 && equal(axlDBDynamicShapes(nil) 0) error("Challenge restore not exact/clean\n"))
  fprintf(f "G_RULE_CHALLENGES_COMPLETE_NO_SAVE\n") close(f) t))
procedure(gFreeze(out board lib refLayer)
 let((f)
  gRuleChallenges(out)
  gGFinalProof(out refLayer)
  unless(axlSaveDesign(?design board ?noMru t ?noConfirm t) error("Frozen board save failed\n"))
  gSnapshot(out lib)
  f=outfile(strcat(out "/freeze.txt"))
  fprintf(f "G_FROZEN_NATIVE_COMPLETE %L\n" board) close(f)
  t))
