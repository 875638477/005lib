procedure(f29CouponPackage(base out)
 let((f ps pads style pn r)
  axlDBChangeDesignUnits("millimeters" 3)
  axlDBChangeDesignExtents(list(-5:-5 5:5))
  f=outfile(out)
  pads=list(make_axlPadStackPad(?layer "TOP" ?type 'REGULAR ?figure 'RECTANGLE ?figureSize 0.2:0.2))
  ps=f29Must(axlDBCreatePadStack("f29_coupon_smd020" nil pads nil) "coupon SMD")
  f29Must(axlPadstackToDisk("f29_coupon_smd020" strcat(base "/f29_coupon_smd020")) "coupon pad export")
  style=make_axlTextOrientation(?textBlock 1 ?justify "center" ?rotation 0 ?mirrored nil)
  foreach(x list(list("1" 0:0.2) list("2" 0:-0.2))
   pn=make_axlPinText(?number car(x) ?offset 0:0 ?text style)
   f29Must(axlDBCreatePin(ps cadr(x) pn 0) "coupon pin"))
  r=car(f29Must(axlDBCreateRectangle(list(-0.4:-0.4 0.4:0.4) t "PACKAGE GEOMETRY/PLACE_BOUND_TOP" nil nil) "coupon PB"))
  f29Must(axlDBAddProp(list(r) list(list("PACKAGE_HEIGHT_MAX" "1 MM"))) "coupon height")
  foreach(l list("REF DES/SILKSCREEN_TOP" "REF DES/ASSEMBLY_TOP")
   f29Must(axlDBCreateText("U*" 0:0 style l nil) "coupon Refdes"))
  f29Must(axlDBCreateText("VALUE" 0:0 style "COMPONENT VALUE/ASSEMBLY_TOP" nil) "coupon Value")
  f29Must(axlSaveDesign(?design strcat(base "/f29_pair_endpoint.dra") ?noConfirm t ?noMru t) "coupon package save")
  f29Must(axlCompileSymbol(?symbol strcat(base "/f29_pair_endpoint")) "coupon package compile")
  fprintf(f "COUPON_PACKAGE_COMPLETE\n") close(f) t))
procedure(f29CouponRoute(f unequal)
 let((p n r)
  f29Must(axlDBCreateLine(list(5:10.2 25:10.2) 0.2 "ETCH/TOP" "CAL_P" nil) "P20mm")
  if(unequal then
   f29Must(axlDBCreateLine(list(5:9.8 10:9.8 10:6 20:6 20:9.8 25:9.8) 0.2 "ETCH/TOP" "CAL_N" nil) "N27.6mm")
  else
   f29Must(axlDBCreateLine(list(5:9.8 25:9.8) 0.2 "ETCH/TOP" "CAL_N" nil) "N20mm"))
  fprintf(f "CAL_P=%L\nCAL_N=%L\n" axlDBFindByName('net "CAL_P")->?? axlDBFindByName('net "CAL_N")->??)))
procedure(f29CouponBuild(base board out)
 let((f comp sym p net pair mark)
  f=outfile(out)
  axlDBChangeDesignUnits("millimeters" 3)
  axlDBChangeDesignExtents(list(-5:-5 40:30))
  axlSetVariable("devpath" list(base))
  axlSetVariable("padpath" list(base))
  axlSetVariable("psmpath" list(base))

  axlDBCreateRectangle(list(0:0 30:20) nil "BOARD GEOMETRY/DESIGN_OUTLINE" nil nil)
  foreach(x list("J901" "J902")
   comp=f29Must(axlDBCreateComponent(x "f29_pair_endpoint") "coupon logical device")
   fprintf(f "COMPONENT\t%L\t%L\n" x comp->??))
  foreach(x list("CAL_P" "CAL_N") f29Must(axlDBCreateNet(x) "coupon net"))
  foreach(x list(list("J901" 5:10) list("J902" 25:10))
   sym=car(f29Must(axlDBCreateSymbol(car(x) cadr(x) nil 0) "coupon placed symbol"))
   foreach(p sym->pins
    net=if(equal(p->number "1") then "CAL_P" else "CAL_N")
    f29Must(axlDBAssignNet(p net nil nil) "coupon pin net")
    fprintf(f "PIN\t%L\t%L\t%L\t%L\n" car(x) p->number p->xy p->net->name)))
  pair=f29Must(axlDiffPair("DP_CALIBRATION" "CAL_P" "CAL_N") "coupon pair")
  foreach(x list('width_min 'neckwidth_min) f29Must(axlCNSSetPhysical("" nil x "0.20 MM") "coupon width"))
  f29Must(axlCNSSetPhysical("" nil 'dp_primary_gap "0.20 MM") "coupon primary gap")
  f29Must(axlCNSSetPhysical("" nil 'dp_min_gap "0.15 MM") "coupon min gap")
  foreach(x axlCNSGetSpacing(nil nil nil)
   unless(member(x list('bbvia_gap 'hole_via 'hole_thrupin 'hole_hole 'hole_shape 'hole_line))
    f29Must(axlCNSSetSpacing("" nil x "0.15 MM") "coupon spacing")))
  f29Must(axlCNSEcsetCreate("E_USB_FS_BUDGET") "coupon ECSet")
  f29Must(axlCNSEcsetValueSet("E_USB_FS_BUDGET" 'Maximum_Via_Count 2) "coupon vias")
  f29Must(axlCNSEcsetValueSet("E_USB_FS_BUDGET" 'Differential_Pair_Phase_Tolerance "1 MM") "coupon phase")
  f29Must(axlCNSEcsetValueSet("E_USB_FS_BUDGET" 'Differential_Pair_Max_Uncoupled_Length "6 MM") "coupon breakout")
  f29Must(axlDBAddProp(list(pair) list(list("ELECTRICAL_CONSTRAINT_SET" "E_USB_FS_BUDGET"))) "coupon ECSet reference")
  f29Must(axlCNSEcsetModeSet('Differential_Pair_Primary_Gap 'on) "coupon DP mode")
  f29Must(axlCNSEcsetModeSet('Maximum_Via_Count 'on) "coupon via mode")
  fprintf(f "ECSET=%L\nMODE=%L\n" axlCNSEcsetValueGet("E_USB_FS_BUDGET" 'all t) axlCNSEcsetModeGet('all))
  mark=axlDBTransactionStart()
  f29CouponRoute(f t)
  fprintf(f "BAD_UPDATE=%L\n" axlDRCUpdate(t)) f29DumpDRC(f "PHASE_UNEQUAL")
  f29Must(axlDBTransactionRollback(mark) "coupon bad rollback")
  f29CouponRoute(f nil)
  fprintf(f "GOOD_UPDATE=%L\n" axlDRCUpdate(t)) f29DumpDRC(f "PHASE_EQUAL")
  f29Must(axlSaveDesign(?design board ?noMru t ?noConfirm t) "coupon saved")
  fprintf(f "COUPON_BUILD_COMPLETE\n") close(f) t))
