procedure(f29Inventory(out)
 let((f des)
  f=outfile(out)
  unless(f error("cannot open output"))
  des=axlDBGetDesign()
  fprintf(f "DESIGN\t%L\t%L\t%L\t%d\t%d\t%d\t%L\n" axlCurrentDesign() axlDBGetDesignUnits() axlSubclassRoute() length(des->components) length(des->nets) length(des->symbols) des->drcState)
  fprintf(f "PHYSICAL_SUPPORTED\t%L\n" axlCNSGetPhysical(nil nil nil))
  fprintf(f "SPACING_SUPPORTED\t%L\n" axlCNSGetSpacing(nil nil nil))
  fprintf(f "ECSET_SUPPORTED\t%L\n" axlCNSEcsetValueGet(nil))
  fprintf(f "PHYSICAL_MODES\t%L\n" axlCNSPhysicalModeGet('all))
  fprintf(f "SPACING_MODES\t%L\n" axlCNSSpacingModeGet('all))
  fprintf(f "ELECTRICAL_MODES\t%L\n" axlCNSEcsetModeGet('all))
  fprintf(f "DESIGN_MODES\t%L\n" axlCNSDesignModeGet('all))
  fprintf(f "DESIGN_SUPPORTED\t%L\n" axlCNSDesignValueGet(nil))
  fprintf(f "PADUSAGE\t%L\n" axlPadstackUsageTypes())
  foreach(domain axlCnsList(nil) fprintf(f "CSETS\t%L\t%L\n" domain axlCnsList(domain)))
  foreach(n des->nets fprintf(f "NET\t%s\t%L\t%L\n" n->name n->?? axlDBGetProperties(n)))
  foreach(c des->netclass fprintf(f "NETCLASS\t%s\t%L\t%L\n" c->name c->?? axlDBGetProperties(c)))
  foreach(l axlSubclassRoute()
   fprintf(f "DEFAULT_PHYSICAL\t%s\t%L\n" l axlCNSGetPhysical("" l nil))
   fprintf(f "DEFAULT_SPACING\t%s\t%L\n" l axlCNSGetSpacing("" l nil))
  )
  fprintf(f "COMPLETE\n")
  close(f)
 )
)
