; Controlled rule challenge geometry. All changes are rolled back; no challenge is saved as product routing.
procedure(f29Via(name xy net)
 let((r)
  f29Must(axlDBAddProp(axlDBFindByName('net net) list("RETAIN_NET_ON_VIAS" t)) "temporary retain-net")
  r=f29Must(axlDBCreateVia(name xy net nil 0 nil) "challenge via")
  unless(equal(car(r)->net->name net) error("Challenge via net not retained\n"))
  car(r)))
procedure(f29Route(points width net)
 let((r)
  r=f29Must(axlDBCreateLine(points width "ETCH/TOP" net nil) "challenge route")
  r))
procedure(f29ChallengeBegin(f name)
 fprintf(f "CHALLENGE_BEGIN\t%s\n" name)
 axlDBTransactionStart())
procedure(f29ChallengeEnd(f mark name)
 fprintf(f "UPDATE\t%s\t%L\n" name axlDRCUpdate(t))
 f29DumpDRC(f name)
 f29Must(axlDBTransactionRollback(mark) strcat(name "/rollback"))
 fprintf(f "ROLLBACK_UPDATE\t%s\t%L\n" name axlDRCUpdate(t))
 f29DumpDRC(f strcat(name "_AFTER")))
procedure(f29Challenges(out)
 let((f mark ps pads dr v r net obj)
  f29Setup()
  f=outfile(strcat(out "/challenges.txt"))
  fprintf(f "INPUT_DRC=%L\n" axlDRCUpdate(t)) f29DumpDRC(f "BASE")
  ; A valid but unapproved padstack used only as the wrong-via test stimulus.
  dr=make_axlPadStackDrill(?usage "Through_via" ?holeType 'CIRCLE_DRILL ?plating 'PLATED ?drillDiameter 0.4 ?figure 'CIRCLE ?figureSize 0.4:0.4)
  pads=nil
  foreach(l list("TOP" "DEFAULT_INTERNAL" "BOTTOM")
   pads=cons(make_axlPadStackPad(?layer l ?type 'REGULAR ?figure 'CIRCLE ?figureSize 0.8:0.8) pads))
  ps=f29Must(axlDBCreatePadStack("f29_unapproved_via040_c080" dr pads nil) "test padstack")
  ; Below the inherited default/NC_DIGITAL_GENERAL minimum neck-width.
  mark=f29ChallengeBegin(f "DEFAULT_WIDTH")
  f29Via("L28_VIA030_C060" 30:25 "GPIO_PA1")
  f29Route(list(30:25 40:25) 0.10 "GPIO_PA1")
  f29ChallengeEnd(f mark "DEFAULT_WIDTH")
  ; Phys CSet inherited by NC_POWER_LV, then direct net-property override.
  mark=f29ChallengeBegin(f "CLASS_POWER_WIDTH")
  f29Via("L28_VIA030_C060" 30:27 "V5")
  f29Route(list(30:27 40:27) 0.30 "V5")
  fprintf(f "UPDATE\tCLASS_POWER_WIDTH\t%L\n" axlDRCUpdate(t)) f29DumpDRC(f "CLASS_POWER_WIDTH")
  net=axlDBFindByName('net "V5")
  f29Must(axlDBAddProp(net list(list("MIN_LINE_WIDTH" "0.20 MM"))) "temporary width override")
  fprintf(f "OVERRIDE_PROP\t%L\n" axlDBGetProperties(net))
  fprintf(f "UPDATE\tNET_OVERRIDE\t%L\n" axlDRCUpdate(t)) f29DumpDRC(f "NET_OVERRIDE")
  f29Must(axlDBTransactionRollback(mark) "net override rollback")
  fprintf(f "ROLLBACK_UPDATE\tNET_OVERRIDE\t%L\n" axlDRCUpdate(t)) f29DumpDRC(f "NET_OVERRIDE_AFTER")
  ; Same class copper gap0.10mm < DEFAULT0.20mm.
  mark=f29ChallengeBegin(f "DEFAULT_SPACING")
  f29Via("L28_VIA030_C060" 30:30 "GPIO_PA1")
  f29Route(list(30:30 40:30) 0.20 "GPIO_PA1")
  f29Via("L28_VIA030_C060" 42:30.3 "GPIO_PA2")
  f29Route(list(32:30.3 42:30.3) 0.20 "GPIO_PA2")
  f29ChallengeEnd(f mark "DEFAULT_SPACING")
  ; Switched-node versus analog class-class exception raises gap to1mm.
  mark=f29ChallengeBegin(f "CLASS_CLASS_ISOLATION")
  f29Via("L28_VIA030_C060" 30:33 "BUCK_SW")
  f29Route(list(30:33 40:33) 0.60 "BUCK_SW")
  f29Via("L28_VIA030_C060" 42:33.9 "ADC0")
  f29Route(list(32:33.9 42:33.9) 0.20 "ADC0")
  f29ChallengeEnd(f mark "CLASS_CLASS_ISOLATION")
  ; The legal via list is a physical rule, not just a text inventory.
  mark=f29ChallengeBegin(f "UNAPPROVED_VIA")
  f29Via("f29_unapproved_via040_c080" 32:36 "GPIO_PA1")
  f29Route(list(32:36 40:36) 0.20 "GPIO_PA1")
  f29ChallengeEnd(f mark "UNAPPROVED_VIA")
  ; Actual electrical max-via count inherited from the differential pair ECSet.
  mark=f29ChallengeBegin(f "USB_MAX_VIA")
  f29Via("L28_VIA030_C060" 30:39 "USB_DP")
  f29Via("L28_VIA030_C060" 34:39 "USB_DP")
  f29Via("L28_VIA030_C060" 38:39 "USB_DP")
  f29Route(list(30:39 38:39) 0.20 "USB_DP")
  fprintf(f "EFFECTIVE_USB_DP_MAXVIA=%L PHASE=%L\n" axlNetEcsetValueGet(axlDBFindByName('net "USB_DP") 'Maximum_Via_Count) axlNetEcsetValueGet(axlDBFindByName('net "USB_DP") 'Differential_Pair_Phase_Tolerance))
  f29ChallengeEnd(f mark "USB_MAX_VIA")

  mark=f29ChallengeBegin(f "L2_POWER_BLOCKED")
  f29Via("L28_VIA030_C060" 30:24 "V3V3")
  f29Must(axlDBCreateLine(list(30:24 40:24) 0.60 "ETCH/L2" "V3V3" nil) "temporary inner power line")
  f29ChallengeEnd(f mark "L2_POWER_BLOCKED")
  mark=f29ChallengeBegin(f "L2_GND_SHAPE_ALLOWED")
  obj=car(f29Must(axlDBCreateRectangle(list(30:24 40:26) t "ETCH/L2" "GND" nil) "temporary GND plane"))
  f29Must(axlDBAssignNet(obj "GND" nil nil) "temporary GND plane net")
  fprintf(f "SHAPE_NET=%L LAYER=%L\n" obj->net->name obj->layer)
  f29ChallengeEnd(f mark "L2_GND_SHAPE_ALLOWED")
  fprintf(f "FINAL_DRC=%L\n" axlDRCUpdate(t)) f29DumpDRC(f "FINAL")
  fprintf(f "CHALLENGES_COMPLETE\n") close(f) t))
