procedure(f29DomainProbe(out)
 let((f nc n r)
  f=outfile(out)
  n=axlDBFindByName('net "GPIO_PA1")
  foreach(test list(list("T_ALL" 'all) list("T_LIST" list('physical 'spacing 'electrical)) list("T_PHYS" 'physical))
   nc=axlNetClassCreate(car(test) cadr(test))
   fprintf(f "CREATE\t%L\t%L\t%L\n" test nc nc->??)
   r=axlNetClassAdd(nc n)
   fprintf(f "ADD\t%L\t%L\n" r nc->??)
   r=axlDBAddProp(list(nc) list(list("PHYSICAL_CONSTRAINT_SET" "P_SIGNAL_020") list("SPACING_CONSTRAINT_SET" "DEFAULT")))
   fprintf(f "PROP\t%L\t%L\t%L\n" r nc->?? axlDBGetProperties(nc))
   fprintf(f "EFFECTIVE\t%L\t%L\t%L\n" axlNetClassGet(n 'physical t) axlNetClassGet(n 'spacing t) axlNetClassGet(n 'electrical t))
  )
  fprintf(f "PROBE_COMPLETE\n") close(f) t))
