axlFilmCreate( "TOP" ?negative nil ?undefineLineWidth 0.0025 ?sequence 1
	?rotation 0 ?xOffset 0.0000 ?yOffset 0.0000 ?shapeBoundingBox 2.5400 ?mirrored nil ?fullContact nil
	?suppressUnconnectPads nil ?drawMissingPadApertures nil ?useApertureRotation nil
	?suppressShapeFill nil ?vectorBasedPad t ?drawHolesOnly nil
	?domains '(ipc2581 pdf artwork visibility ) ?ipc2581 '()
	?layers '("ETCH/TOP" "PIN/TOP" "VIA CLASS/TOP" "BOARD GEOMETRY/OUTLINE" ))
axlFilmCreate( "BOTTOM" ?negative nil ?undefineLineWidth 0.0025 ?sequence 27
	?rotation 0 ?xOffset 0.0000 ?yOffset 0.0000 ?shapeBoundingBox 2.5400 ?mirrored nil ?fullContact nil
	?suppressUnconnectPads nil ?drawMissingPadApertures nil ?useApertureRotation nil
	?suppressShapeFill nil ?vectorBasedPad t ?drawHolesOnly nil
	?domains '(ipc2581 pdf artwork visibility ) ?ipc2581 '()
	?layers '("ETCH/BOTTOM" "PIN/BOTTOM" "VIA CLASS/BOTTOM" "BOARD GEOMETRY/OUTLINE" ))
axlFilmCreate("F28_DESIGN_OUTLINE" ?negative nil ?undefineLineWidth 0.0025 ?sequence 100 ?rotation 0 ?xOffset 0 ?yOffset 0 ?shapeBoundingBox 2.54 ?mirrored nil ?fullContact nil ?suppressUnconnectPads nil ?drawMissingPadApertures nil ?useApertureRotation nil ?suppressShapeFill nil ?vectorBasedPad t ?drawHolesOnly nil ?layers '("BOARD GEOMETRY/DESIGN_OUTLINE"))
