; Native Lesson28: build isolated 2/4 layer targets and export independent readback.
procedure(l28PadRow(f p ref layer)
 let((v bb)
 v=axlDBGetPad(p layer "REGULAR") bb=if(v then v->bBox else nil)
 fprintf(f "%L\t%L\t%L\t%L\t%L\t%L\t%L\n" ref p->number p->name layer if(v then v->figureName else nil) bb if(axlIsDBIDType(p->net) then p->net->name else nil))))
procedure(l28Read(out)
 let((f xf cf nf pf gf vf af d xs c s p n o v lay g)
 f=outfile(strcat(out "/readback.txt"))
 xf=outfile(strcat(out "/cross_section.tsv"))
 cf=outfile(strcat(out "/components.tsv"))
 nf=outfile(strcat(out "/nets.tsv"))
 pf=outfile(strcat(out "/pads.tsv"))
 gf=outfile(strcat(out "/geometry.tsv"))
 vf=outfile(strcat(out "/vias.tsv"))
 af=outfile(strcat(out "/films.tsv"))
 d=axlDBGetDesign()
 fprintf(f "L28_READ START\nname=%L units=%L type=%L components=%d symbols=%d nets=%d total_thickness=%L drc_count=%d drc_state=%L\n" axlCurrentDesign() axlDBGetDesignUnits() axlDesignType(t) length(d->components) length(d->symbols) length(d->nets) axlXSectionGet(nil 'thickness) length(d->drcs) d->drcState)
 fprintf(xf "position\tname\ttype\tfunction\tmaterial\tthickness\ttolPlus\ttolMinus\tdk\tloss\tconductivity\tnegative\tconductor\tmfg\n")
 foreach(xs axlXSectionGet(nil 'all)
  fprintf(xf "%L\t%L\t%L\t%L\t%L\t%L\t%L\t%L\t%L\t%L\t%L\t%L\t%L\t%L\n" xs->position xs->name xs->layerType xs->layerFunction xs->material xs->thickness xs->tolPlus xs->tolMinus xs->dielectricConst xs->lossTangent xs->conductivity xs->negativeArtwork xs->conductor xs->mfg))
 fprintf(cf "refdes\tdevice_type\tpackage\tsymbol\txy\trotation\tmirrored\tpins\n")
 fprintf(pf "refdes\tnumber\tpadstack\tlayer\tfigure\tbbox\tnet\n")
 foreach(c d->components
  s=c->symbol
  fprintf(cf "%L\t%L\t%L\t%L\t%L\t%L\t%L\t%d\n" c->name c->deviceType c->package if(s then s->name else nil) if(s then s->xy else nil) if(s then s->rotation else nil) if(s then s->isMirrored else nil) length(c->pins))
  foreach(p c->pins
   foreach(lay list("ETCH/TOP" "ETCH/L2" "ETCH/L3" "ETCH/BOTTOM")
    when(axlIsLayer(lay) l28PadRow(pf p c->name lay)))))
 fprintf(nf "net\tnumberOfPins\tpinIdentities\n")
 foreach(n d->nets
  fprintf(nf "%L\t%d\t" n->name length(n->pins))
  foreach(p n->pins fprintf(nf "%L " p->name))
  fprintf(nf "\n"))
 fprintf(gf "type\tlayer\tbbox\txypoints\ttext\tproperties\n")
 fprintf(vf "name\txy\tplating\tdiameter\tdrillX\tdrillY\tthrough\tstartEnd\tnet\tusage\n")
 foreach(o axlExtractMap("C:/Program0/Cadence/SPB172/share/pcb/text/views/fgeo_bv.txt" nil)
  when(equal(o->objType "via")
   v=o->definition
   fprintf(vf "%L\t%L\t%L\t%L\t%L\t%L\t%L\t%L\t%L\t%L\n" o->name o->xy v->plating v->drillDiameter v->drillSizeWidth v->drillSizeHeight o->isThrough o->startEnd if(axlIsDBIDType(o->net) then o->net->name else nil) v->usage)
   foreach(lay list("ETCH/TOP" "ETCH/L2" "ETCH/L3" "ETCH/BOTTOM")
    when(axlIsLayer(lay) l28PadRow(pf o "VIA_TEST" lay))))
  when(member(o->objType list("shape" "line" "text" "arc"))
   g=if(member(o->objType list("shape" "line" "arc")) then axlPolyFromDB(o) else nil)
   fprintf(gf "%L\t%L\t%L\t%L\t%L\t%L\n" o->objType o->layer o->bBox if(g then car(g)->vertices else nil) if(equal(o->objType "text") then o->text else nil) axlDBGetProperties(o nil))))
 fprintf(af "name\tproperties\n")
 g=axlGetParam("artwork")
 foreach(n g->groupMembers
  v=axlGetParam(strcat("artwork:" n))
  fprintf(af "%L\t%L\n" n v->??))
 fprintf(f "L28_READ COMPLETE\n")
 foreach(o list(f xf cf nf pf gf vf af) close(o)) t))
procedure(l28Set(xs attrs)
 unless(axlXSectionSet(xs attrs) error("Cross section set failed\n")))
procedure(l28Build(n board out native)
 let((f xs die old ds obj ret th maskth)
 f=outfile(strcat(out "/build.txt"))
 fprintf(f "L28_BUILD START layerTarget=%d source=%L\n" n axlCurrentDesign())
 unless(equal(car(axlDBGetDesignUnits()) "millimeters") error("Expected mm source\n"))
 old=nil die=nil
 foreach(xs axlXSectionGet(nil 'all)
  when(xs->conductor old=append(old list(xs->name)))
  when(equal(xs->layerType "DIELECTRIC") die=cons(xs die)))
 unless(equal(old list("TOP" "BOTTOM")) error("Expected 2-layer mechanical source\n"))
 unless(length(die)==1 error("Expected single starting dielectric\n"))
 if(n==2 then
  th=0.0356 maskth=0.0152
  l28Set(car(die) axlXSectionModify(?material "L28_OSH_KB6167F_CORE" ?thickness 1.524 ?tolPlus 0.1524 ?tolMinus 0.1524 ?dielectricConst "4.5" ?mfg "CORE_60MIL_DK_AT_10MHZ"))
 else
  th=0.035 maskth=0.01524
  l28Set(car(die) axlXSectionModify(?material "L28_JLC_PP7628" ?thickness 0.2104 ?dielectricConst "4.4" ?mfg "PREPREG_7628_1"))
  unless(axlXSectionCreate(nil 'bottom axlXSectionModify(?name "L2" ?layerType "CONDUCTOR" ?material "COPPER" ?thickness 0.0152 ?mfg "INNER_0P5OZ")) error("L2 failed\n"))
  unless(axlXSectionCreate(nil 'bottom axlXSectionModify(?layerType "DIELECTRIC" ?material "L28_JLC_CORE_FR4" ?thickness 1.065 ?dielectricConst "4.6" ?mfg "CORE_DIELECTRIC_EXCLUDING_COPPER")) error("Core failed\n"))
  unless(axlXSectionCreate(nil 'bottom axlXSectionModify(?name "L3" ?layerType "CONDUCTOR" ?material "COPPER" ?thickness 0.0152 ?mfg "INNER_0P5OZ")) error("L3 failed\n"))
  unless(axlXSectionCreate(nil 'bottom axlXSectionModify(?layerType "DIELECTRIC" ?material "L28_JLC_PP7628" ?thickness 0.2104 ?dielectricConst "4.4" ?mfg "PREPREG_7628_1")) error("Bottom PP failed\n")))
 foreach(s list("TOP" "BOTTOM")
  l28Set(axlXSectionGet(nil s) axlXSectionModify(?material "COPPER" ?thickness th ?negativeArtwork nil ?mfg "FINISHED_OUTER_COPPER")))
 ; The 2L mask permittivity is not specified for purple on the source page; keep it unqualified.
 if(n==2 then
  ds=axlXSectionModify(?name "SOLDERMASK_TOP" ?layerType "MASK" ?material "L28_OSH_PURPLE_MASK_DK_UNSPECIFIED" ?thickness maskth ?tolPlus 0.00508 ?tolMinus 0.00508 ?mfg "SOURCE_MASK_DK_NOT_QUALIFIED")
 else
  ds=axlXSectionModify(?name "SOLDERMASK_TOP" ?layerType "MASK" ?material "L28_JLC_MASK_EFFECTIVE_C2" ?thickness maskth ?dielectricConst "3.8" ?mfg "EFFECTIVE_ABOVE_TRACE_C2_NOT_CONTOUR"))
 unless(axlXSectionCreate(nil 'top ds) error("Top mask failed\n"))
 ds->name="SOLDERMASK_BOTTOM"
 unless(axlXSectionCreate(nil 'afterBottom ds) error("Bottom mask failed\n"))
 axlSetVariable("padpath" list(native))
 unless(axlLoadPadstack("l28_via030_c060") error("Via padstack load failed\n"))
 ret=axlDBCreateVia("l28_via030_c060" 52:35 "GND" nil 0 nil)
 unless(ret error("Layer mapping teaching via failed\n"))
 fprintf(f "VIA_CREATE=%L DRC=%L\n" car(ret) cadr(ret))
 ; Controlled edit, measured independent raw values, then restore; no mismatch is saved as final.
 xs=axlXSectionGet(nil "TOP") old=xs->thickness
 l28Set(xs axlXSectionModify(?thickness old+0.01))
 fprintf(f "CONTROLLED_BAD_THICKNESS target=%L observed=%L detected=%L\n" old xs->thickness abs(xs->thickness-old)>0.005)
 l28Set(xs axlXSectionModify(?thickness old))
 fprintf(f "RESTORED_THICKNESS=%L\n" xs->thickness)
 load(strcat(native if(n==2 then "/copper_films_2_exact.il" else "/copper_films_4_exact.il")))
 fprintf(f "FULL_DRC_RETURN=%L\n" axlDRCUpdate(t))
 fprintf(f "FINAL_DRC_COUNT=%d STATE=%L\n" length(axlDBGetDesign()->drcs) axlDBGetDesign()->drcState)
 unless(axlSaveDesign(?design board ?noMru t ?noConfirm t) error("Save failed\n"))
 fprintf(f "L28_BUILD COMPLETE\n") close(f) t))

procedure(l28FilmFix(n board out native)
 let((f)
 f=outfile(strcat(out "/fix.txt"))
 load(strcat(native if(n==2 then "/copper_films_2_exact.il" else "/copper_films_4_exact.il")))
 fprintf(f "FULL_DRC_RETURN=%L COUNT=%d STATE=%L\n" axlDRCUpdate(t) length(axlDBGetDesign()->drcs) axlDBGetDesign()->drcState)
 unless(axlSaveDesign(?design board ?noMru t ?noConfirm t) error("Film correction save failed\n"))
 fprintf(f "L28_FILM_FIX COMPLETE\n") close(f) t))
