procedure(l7cPackage(libDir outDir)
 let((f drill pads ps style result bound)
  unless(equal(axlCurrentDesign() "eda_l07c_null_npth_coupon") error("Wrong package\n"))
  axlDBChangeDesignUnits("millimeters" 3)
  axlDBChangeDesignExtents(list(-15:-10 15:10))
  axlSetVariable("padpath" list(libDir "D:/001DIY/005lib/01AIEDA/learning/examples/lesson07_padstacks/library"))
  axlSetVariable("psmpath" list(libDir))
  f=outfile(strcat(outDir "/create.txt"))
  drill=make_axlPadStackDrill(?usage "MECH_HOLE" ?holeType 'CIRCLE_DRILL ?plating 'NON_PLATED ?drillDiameter 2.0 ?figure 'CIRCLE ?figureSize 2.0:2.0)
  pads=nil
  foreach(layer list("TOP" "DEFAULT_INTERNAL" "BOTTOM")
   pads=cons(make_axlPadStackPad(?layer layer ?type 'REGULAR ?figure 'NULL ?figureSize 0:0) pads))
  foreach(layer list("SOLDERMASK_TOP" "SOLDERMASK_BOTTOM")
   pads=cons(make_axlPadStackPad(?layer layer ?type 'REGULAR ?figure 'CIRCLE ?figureSize 2.2:2.2) pads))
  ps=axlDBCreatePadStack("eda_l07c_npth_200_null" drill pads nil)
  fprintf(f "checked_create=%L\n" ps)
  unless(ps error("Checked NPTH create failed\n"))
  unless(axlPadstackToDisk("eda_l07c_npth_200_null" strcat(libDir "/eda_l07c_npth_200_null")) error("Pad save failed\n"))
  unless(axlDBCreatePin(ps 0:0 nil 0) error("NPTH pin failed\n"))
  style=make_axlTextOrientation(?textBlock "2" ?rotation 0 ?mirrored nil ?justify "center")
  ps=axlLoadPadstack("eda_l07_pth_080_c160")
  unless(ps error("PTH load failed\n"))
  foreach(c list(list(-5:0 "1" 0) list(5:0 "2" 90))
   result=axlDBCreatePin(ps car(c) make_axlPinText(?number cadr(c) ?offset 0:0 ?text style) caddr(c))
   unless(result error("PTH failed\n")))
  result=axlDBCreateRectangle(list(-1.5:-1.5 1.5:1.5) t "ROUTE KEEPOUT/ALL" nil nil)
  fprintf(f "package_route_keepout=%L\n" result)
  unless(result error("Route keepout failed\n"))
  result=axlDBCreateRectangle(list(-7:-3 7:3) t "PACKAGE GEOMETRY/PLACE_BOUND_TOP" nil nil)
  bound=car(result)
  unless(axlDBAddProp(list(bound) list("PACKAGE_HEIGHT_MAX" "1 MM")) error("Height failed\n"))
  foreach(layer list("REF DES/SILKSCREEN_TOP" "REF DES/ASSEMBLY_TOP")
   unless(axlDBCreateText("U*" 0:0 style layer nil) error("Refdes failed\n")))
  unless(axlDBCreateText("VALUE" 0:0 style "COMPONENT VALUE/ASSEMBLY_TOP" nil) error("Value failed\n"))
  unless(axlSaveDesign(?design strcat(libDir "/eda_l07c_null_npth_coupon.dra") ?noMru t ?noConfirm t) error("Save failed\n"))
  unless(axlCompileSymbol(?symbol strcat(libDir "/eda_l07c_null_npth_coupon")) error("Compile failed\n"))
  fprintf(f "L7C_PACKAGE COMPLETE\n")
  close(f)
  t))
