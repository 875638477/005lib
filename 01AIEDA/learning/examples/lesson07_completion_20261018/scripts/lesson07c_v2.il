procedure(l7cPackage(libDir outDir)
 let((f drill pads ps style result bound)
  unless(equal(axlCurrentDesign() "eda_l07c_null_npth_coupon") error("Wrong package\n"))
  axlDBChangeDesignUnits("millimeters" 3)
  axlDBChangeDesignExtents(list(-15:-10 15:10))
  axlSetVariable("padpath" list(libDir "D:/001DIY/005lib/01AIEDA/learning/examples/lesson07_padstacks/library"))
  axlSetVariable("psmpath" list(libDir))
  f=outfile(strcat(outDir "/create.txt"))
  ps=axlLoadPadstack("eda_l07c_npth_200_null")
  unless(ps error("Pure NULL padstack load failed\n"))
  fprintf(f "xml_NULL_load=%L hole=%L plating=%L usage=%L\n" ps ps->drillDiameter ps->plating ps->usage)
  unless(axlDBCreatePin(ps 0:0 nil 0) error("NPTH pin failed\n"))
  style=make_axlTextOrientation(?textBlock "2" ?rotation 0 ?mirrored nil ?justify "center")
  ps=l7cPth(libDir)
  unless(ps error("PTH load failed\n"))
  foreach(c list(list(-5:0 "1" 0) list(5:0 "2" 90))
   result=axlDBCreatePin(ps car(c) make_axlPinText(?number cadr(c) ?offset 0:0 ?text style) caddr(c))
   unless(result error("PTH failed\n")))
  result=axlDBCreateRectangle(list(-1.5:-1.5 1.5:1.5) t "ROUTE KEEPOUT/ALL" nil nil)
  fprintf(f "package_route_keepout=%L\n" result)
  unless(result error("Route keepout failed\n"))
  result=axlDBCreateRectangle(list(-7:-3 7:3) t "PACKAGE GEOMETRY/PLACE_BOUND_TOP" nil nil)
  bound=car(result)
  unless(axlDBAddProp(list(bound) list("PACKAGE_HEIGHT_MAX" "1 MM")) error("Height failed\n"))
  foreach(layer list("REF DES/SILKSCREEN_TOP" "REF DES/ASSEMBLY_TOP")
   unless(axlDBCreateText("U*" 0:0 style layer nil) error("Refdes failed\n")))
  unless(axlDBCreateText("VALUE" 0:0 style "COMPONENT VALUE/ASSEMBLY_TOP" nil) error("Value failed\n"))
  unless(axlSaveDesign(?design strcat(libDir "/eda_l07c_null_npth_coupon.dra") ?noMru t ?noConfirm t) error("Save failed\n"))
  unless(axlCompileSymbol(?symbol strcat(libDir "/eda_l07c_null_npth_coupon")) error("Compile failed\n"))
  fprintf(f "L7C_PACKAGE COMPLETE\n")
  close(f)
  t))
procedure(l7cRotate(p angle)
 let((a) a=angle*acos(-1)/180.0 (car(p)*cos(a)-cadr(p)*sin(a)):(car(p)*sin(a)+cadr(p)*cos(a))))
procedure(l7cFlash(libDir outDir)
 let((f a b c d h ri ro path result)
  unless(equal(axlCurrentDesign() "eda_l07c_th4_200_160_w30_d80") error("Wrong flash\n"))
  axlDBChangeDesignUnits("millimeters" 3)
  axlDBChangeDesignExtents(list(-3:-3 3:3))
  f=outfile(strcat(outDir "/create.txt"))
  ri=0.8 ro=1.0 h=0.15
  a=sqrt(ri*ri-h*h):h b=h:sqrt(ri*ri-h*h)
  c=h:sqrt(ro*ro-h*h) d=sqrt(ro*ro-h*h):h
  foreach(angle list(0 90 180 270)
   path=axlPathStart(list(l7cRotate(a angle)) 0.0)
   axlPathArcCenter(path 0.0 l7cRotate(b angle) nil 0:0)
   axlPathLine(path 0.0 l7cRotate(c angle))
   axlPathArcCenter(path 0.0 l7cRotate(d angle) t 0:0)
   axlPathLine(path 0.0 l7cRotate(a angle))
   result=axlDBCreateShape(path t "ETCH/TOP" nil nil)
   unless(result error("Thermal quadrant failed\n"))
   fprintf(f "quadrant=%L bbox=%L\n" angle car(result)->bBox))
  unless(axlDBCreateShape(axlPathStartCircle(list(0:0 0.4) 0.0) t "ETCH/TOP" nil nil) error("Center dot failed\n"))
  unless(axlSaveDesign(?design strcat(libDir "/eda_l07c_th4_200_160_w30_d80.dra") ?noMru t ?noConfirm t) error("Flash save failed\n"))
  unless(axlCompileSymbol(?symbol strcat(libDir "/eda_l07c_th4_200_160_w30_d80")) error("Flash compile failed\n"))
  fprintf(f "L7C_FLASH COMPLETE\n") close(f) t))
procedure(l7cPth(libDir)
 let((ps drill pads)
  axlSetVariable("padpath" list(libDir))
  drill=make_axlPadStackDrill(?usage "Through_pin" ?holeType 'CIRCLE_DRILL ?plating 'PLATED ?drillDiameter 0.8)
  pads=nil
  foreach(layer list("TOP" "DEFAULT_INTERNAL" "BOTTOM")
   pads=cons(make_axlPadStackPad(?layer layer ?type 'REGULAR ?figure 'CIRCLE ?figureSize 1.6:1.6) pads)
   pads=cons(make_axlPadStackPad(?layer layer ?type 'THERMAL ?figure 'FLASH ?flash "eda_l07c_th4_200_160_w30_d80" ?figureSize 2.0:2.0) pads)
   pads=cons(make_axlPadStackPad(?layer layer ?type 'ANTIPAD ?figure 'CIRCLE ?figureSize 2.0:2.0) pads))
  foreach(layer list("SOLDERMASK_TOP" "SOLDERMASK_BOTTOM")
   pads=cons(make_axlPadStackPad(?layer layer ?type 'REGULAR ?figure 'CIRCLE ?figureSize 1.8:1.8) pads))
  ps=axlDBCreatePadStack("eda_l07c_pth_080_c160_th4" drill pads nil)
  unless(ps error("Checked PTH flash pad failed\n"))
  unless(axlPadstackToDisk(ps->name strcat(libDir "/eda_l07c_pth_080_c160_th4")) error("PTH pad save failed\n"))
  ps))
procedure(l7cBoard(libDir outDir)
 let((f xs definition result saved pin ps shape update drc path mark challenge)
  unless(equal(axlCurrentDesign() "eda_l07c_clearance_4layer_v2") error("Wrong board\n"))
  axlDBChangeDesignUnits("millimeters" 3)
  axlDBChangeDesignExtents(list(0:0 40:40))
  axlSetVariable("padpath" list(libDir)) axlSetVariable("psmpath" list(libDir))
  f=outfile(strcat(outDir "/create.txt"))
  foreach(name list("L2" "L3")
   definition=axlXSectionModify(?name name ?layerType "CONDUCTOR" ?material "COPPER" ?thickness 0.035)
   unless(axlXSectionCreate(nil 'bottom definition) error("Conductor failed\n"))
   definition=axlXSectionModify(?layerType "DIELECTRIC" ?material "FR-4" ?thickness 0.4)
   unless(axlXSectionCreate(nil 'bottom definition) error("Dielectric failed\n")))
  unless(axlSetPlaneType("L3" "Negative") error("Negative L3 failed\n"))
  unless(axlDBCreateNet("GND") error("GND net failed\n"))
  unless(axlDBCreateNet("OTHER") error("OTHER net failed\n"))
  axlSetVariable("devpath" list(libDir))
  unless(axlDBCreateComponent("U1" "eda_l07c_coupon_device") error("Teaching logical component failed\n"))
  result=axlDBCreateSymbol("U1" 20:20 nil 0)
  unless(result error("Symbol failed\n"))
  fprintf(f "placed_pin_count=%d\n" length(car(result)->pins))
  unless(length(car(result)->pins)==3 error("Placed symbol pin list is not ready\n"))
  foreach(pin car(result)->pins
   cond((equal(pin->number "1") unless(axlDBAssignNet(pin "GND" t) error("GND pin assign failed\n")))
        (equal(pin->number "2") unless(axlDBAssignNet(pin "OTHER" t) error("OTHER pin assign failed\n")))))
  unless(axlDBCreateRectangle(list(10:14 30:26) nil "BOARD GEOMETRY/OUTLINE" nil nil) error("Outline failed\n"))
  foreach(layer list("TOP" "L2" "BOTTOM")
   result=axlDBCreateRectangle(list(11:15 29:25) t strcat("BOUNDARY/" layer) "GND" nil)
   unless(result error("Dynamic shape create failed\n"))
   unless(axlDBAssignNet(car(result) "GND" t) error("Dynamic boundary GND assignment failed\n"))
   fprintf(f "dynamic_layer=%L created=%L net=%L\n" layer car(result) car(result)->net->name))
  path=axlPathStart(list(11:15 29:15 29:25 11:25 11:15) 0.0)
  shape=axlDBCreateOpenShape(path t "ETCH/L3" "GND" nil)
  unless(shape error("Static negative plane failed\n"))
  path=axlPathStart(list(18.5:18.5 21.5:18.5 21.5:21.5 18.5:21.5 18.5:18.5) 0.0)
  unless(axlDBCreateVoid(shape path) error("Explicit NPTH plane void failed\n"))
  unless(axlDBCreateCloseShape(shape) error("Static shape close failed\n"))
  update=axlShapeDynamicUpdate(nil t)
  fprintf(f "dynamic_update=%L\n" update)
  unless(equal(update 0) error("Dynamic shape update failed\n"))
  mark=axlDBTransactionStart()
  unless(mark error("Challenge transaction failed\n"))
  challenge=axlDBCreatePath(axlPathStart(list(19:20 21:20) 0.2) "ETCH/TOP" "OTHER" nil)
  unless(challenge error("Controlled keepout intrusion failed\n"))
  drc=axlDRCUpdate(t)
  fprintf(f "controlled_intrusion_drc=%L\n" drc)
  foreach(d axlDBGetDesign()->drcs fprintf(f "CONTROLLED_DRC=%L\n" d->??))
  unless(drc>0 error("Keepout challenge was not detected\n"))
  unless(axlDBTransactionRollback(mark) error("Challenge rollback failed\n"))
  unless(equal(axlShapeDynamicUpdate(nil t) 0) error("Post-rollback copper update failed\n"))
  drc=axlDRCUpdate(t)
  fprintf(f "drc_update=%L state=%L\n" drc axlDBGetDesign()->drcState)
  foreach(layer list("TOP" "L2" "L3" "BOTTOM")
   unless(axlFilmCreate(layer ?layers list(strcat("ETCH/" layer)) ?negative nil ?undefineLineWidth 0.1 ?vectorBasedPad t) error("Film failed\n")))
  unless(axlSaveDesign(?design strcat(libDir "/eda_l07c_clearance_4layer_v2.brd") ?noMru t ?noConfirm t) error("Board save failed\n"))
  fprintf(f "L7C_BOARD COMPLETE\n") close(f) t))
procedure(l7cRead(outDir)
 let((f pin ps pad pins layer shape poly hole tpoly maps text bound xs probe ints area ip layers connection seg)
  f=outfile(strcat(outDir "/readback.txt"))
  fprintf(f "design=%L type=%L units=%L drc_state=%L stored_drcs=%d\n" axlCurrentDesign() axlDesignType(t) axlDBGetDesignUnits() axlDBGetDesign()->drcState length(axlDBGetDesign()->drcs))
  layers=nil
  foreach(xs axlXSectionGet(nil 'all)
   fprintf(f "STACK\t%L\t%L\t%L\n" xs->name xs->layerType xs->negativeArtwork)
   when(equal(xs->layerType "CONDUCTOR") layers=append(layers list(strcat("ETCH/" xs->name)))))
  pins=axlDBGetDesign()->pins
  unless(pins foreach(sym axlDBGetDesign()->symbols pins=append(pins sym->pins)))
  foreach(pin pins
   ps=pin->definition
   fprintf(f "PIN\t%L\t%L\t%L\t%L\t%L\t%L\t%L\t%L\n" pin->name pin->number pin->xy pin->rotation pin->isMech ps->holeType ps->plating ps->drillDiameter)
   fprintf(f "PIN_NET\t%L\t%L\t%L\n" pin->number ps->usage if(axlIsDBIDType(pin->net) then pin->net->name else nil))
   foreach(layer layers
    foreach(kind list("REGULAR" "THERMAL" "ANTI" "KEEPOUT")
     pad=axlDBGetPad(pin layer kind)
     fprintf(f "PAD\t%L\t%L\t%L\t%L\t%L\t%L\n" pin->name layer kind if(pad then pad->figureName else nil) if(pad then pad->bBox else nil) if(pad then pad->flash else nil)))
    tpoly=axlPolyFromDB(pin ?layer layer ?padType 'THERMAL)
    foreach(poly tpoly fprintf(f "THERMAL_POLY\t%L\t%L\t%L\t%L\t%L\n" pin->name layer poly->bBox poly->area poly->vertices))))
  foreach(shape axlDBGetShapes("BOUNDARY") fprintf(f "BOUNDARY_NET\t%L\t%L\t%L\n" shape->layer shape->bBox if(axlIsDBIDType(shape->net) then shape->net->name else nil)))
  foreach(pin pins
   foreach(connection axlDBGetConnect(pin t)
    fprintf(f "CONNECT\t%L\t%L\t%L\t%L\n" pin->number connection->objType connection->layer if(axlIsDBIDType(connection->net) then connection->net->name else nil))
    when(equal(connection->objType "path") && connection->thermal
     foreach(seg connection->segments
      fprintf(f "THERMAL_CLINE\t%L\t%L\t%L\t%L\t%L\n" pin->number seg->layer seg->width seg->startEnd connection->net->name)
      foreach(poly axlPolyFromDB(seg) fprintf(f "THERMAL_COPPER_POLY\t%L\t%L\t%L\t%L\n" pin->number seg->layer poly->bBox poly->area))))))
  foreach(layer append(layers list("ROUTE KEEPOUT/ALL"))
   foreach(shape axlDBGetShapes(layer)
    fprintf(f "SHAPE\t%L\t%L\t%L\t%L\t%L\t%L\n" layer shape->bBox shape->shapeBoundary shape->shapeIsBoundary shape->fillOOD if(axlIsDBIDType(shape->net) then shape->net->name else nil))
    foreach(poly axlPolyFromDB(shape)
     fprintf(f "COPPER_POLY\t%L\t%L\t%L\t%L\n" layer poly->bBox poly->area poly->vertices)
     foreach(hole poly->holes
      fprintf(f "VOID\t%L\t%L\t%L\t%L\n" layer hole->bBox hole->area hole->vertices)))))
  when(equal(axlDesignType(t) "BOARD")
   probe=axlPolyFromDB(axlPathStartCircle(list(20:20 1.49) 0.0))
   foreach(layer layers
    area=0.0
    foreach(shape axlDBGetShapes(layer)
     foreach(poly axlPolyFromDB(shape)
      ints=axlPolyOperation(list(poly) probe 'AND)
      unless(ints error("Copper intersection operation failed\n"))
      foreach(ip ints when(ip area=area+ip->area))))
    fprintf(f "NPTH_CLEAR_PROBE\t%L\t%L\n" layer area)))
  foreach(text axlDBGetDesign()->text fprintf(f "TEXT\t%L\t%L\t%L\n" text->layer text->text text->xy))
  foreach(bound axlDBGetShapes("PACKAGE GEOMETRY/PLACE_BOUND_TOP") fprintf(f "HEIGHT\t%L\n" axlDBGetProperties(bound nil)))
  foreach(drc axlDBGetDesign()->drcs fprintf(f "DRC\t%L\n" drc->??))
  fprintf(f "L7C_READ COMPLETE\n") close(f) t))
