; Lesson05: all writes restricted to a fresh isolated BOARD.
procedure(l5Dump(symbols outDir)
 let((sf pf cf s p o pad layer box polys poly)
  sf=outfile(strcat(outDir "/symbols.tsv"))
  pf=outfile(strcat(outDir "/pins.tsv"))
  cf=outfile(strcat(outDir "/children.tsv"))
  unless(sf && pf && cf error("Cannot open snapshot files\n"))
  fprintf(sf "name\tx\ty\trotation\tmirrored\trefdes\tpins\tchildren\n")
  fprintf(pf "sx\tsy\tnumber\tx\ty\trelx\trely\trotation\trelrotation\tmirrored\tlayer\tfigure\tbbox\ton_layer\tpoly_bbox\tpoly_vertices\n")
  fprintf(cf "sx\tsy\ttype\tlayer\tbbox\ttext\tx\ty\trotation\tmirrored\tfilled\tprops\n")
  foreach(s symbols
   s=axlDBRefreshId(s)
   fprintf(sf "%L\t%L\t%L\t%L\t%L\t%L\t%d\t%d\n" s->name car(s->xy) cadr(s->xy) s->rotation s->isMirrored s->refdes length(s->pins) length(s->children))
   foreach(p s->pins
    p=axlDBRefreshId(p)
    foreach(layer list("ETCH/TOP" "ETCH/BOTTOM" "PIN/SOLDERMASK_TOP" "PIN/SOLDERMASK_BOTTOM" "PIN/PASTEMASK_TOP" "PIN/PASTEMASK_BOTTOM")
     pad=axlDBGetPad(p layer "REGULAR")
     polys=if(member(layer list("ETCH/TOP" "ETCH/BOTTOM")) then axlPolyFromDB(p ?layer layer ?padType 'REGULAR) else nil)
     poly=car(polys)
     fprintf(pf "%L\t%L\t%L\t%L\t%L\t%L\t%L\t%L\t%L\t%L\t%L\t%L\t%L\t%L\t%L\t%L\n"
      car(s->xy) cadr(s->xy) p->number car(p->xy) cadr(p->xy) car(p->relxy) cadr(p->relxy)
      p->rotation p->relRotation p->isMirrored layer
      if(pad then pad->figureName else nil) if(pad then pad->bBox else nil)
      axlPadOnLayer(p if(member(layer list("ETCH/TOP" "PIN/SOLDERMASK_TOP" "PIN/PASTEMASK_TOP")) then "TOP" else "BOTTOM"))
      if(poly then poly->bBox else nil) if(poly then poly->vertices else nil))
    )
   )
   foreach(o s->children
    o=axlDBRefreshId(o)
    fprintf(cf "%L\t%L\t%L\t%L\t%L\t%L\t%L\t%L\t%L\t%L\t%L\t%L\n"
      car(s->xy) cadr(s->xy) o->objType o->layer o->bBox
      if(equal(o->objType "text") then o->text else nil)
      if(equal(o->objType "text") then car(o->xy) else nil)
      if(equal(o->objType "text") then cadr(o->xy) else nil)
      if(equal(o->objType "text") then o->rotation else nil)
      if(equal(o->objType "text") then o->isMirrored else nil)
      if(equal(o->objType "shape") then o->fill else nil)
      axlDBGetProperties(o nil))
   )
  )
  foreach(o list(sf pf cf) close(o))
  t
 )
)
procedure(l5Create(base)
 let((f a b c r syms saved oldId)
  unless(equal(axlCurrentDesign() "lesson05_instances") && equal(axlDesignType(t) "BOARD") error("Unexpected lesson05 drawing\n"))
  f=outfile(strcat(base "/logs/create02/operations.txt"))
  fprintf(f "LESSON05 START\n")
  axlDBChangeDesignUnits("millimeters" 3)
  unless(axlDBChangeDesignExtents(list(-30.0:-15.0 30.0:15.0)) error("Extents failed\n"))
  axlSetVariable("padpath" list("D:/001DIY/005lib/01Pad_lib" "D:/001DIY/005lib/01Psm_lib"))
  axlSetVariable("psmpath" list("D:/001DIY/005lib/01Psm_lib"))
  a=car(axlDBCreateSymbol(list("qmi8610_lga16_3d3_p0d5" "PACKAGE") -10.0:-2.0 nil 0.0))
  b=car(axlDBCreateSymbol(list("qmi8610_lga16_3d3_p0d5" "PACKAGE") 0.0:-2.0 nil 0.0))
  c=car(axlDBCreateSymbol(list("qmi8610_lga16_3d3_p0d5" "PACKAGE") 10.0:-2.0 nil 0.0))
  unless(a && b && c error("Public PSM load failed\n"))
  l5Dump(list(a b c) strcat(base "/logs/create02/before"))
  r=axlTransformObject(a ?move 1.877:5.456 ?allOrNone t)
  unless(r error("Move failed\n")) a=if(axlIsDBIDType(r) then r else car(r)) a=axlDBRefreshId(a)
  fprintf(f "MOVE delta=(1.877 5.456) actual=%L\n" a->xy)
  unless(equal(a->xy -8.123:3.456) error("Move target mismatch\n"))
  r=axlTransformObject(b ?angle 90.0 ?origin b->xy ?allOrNone t)
  unless(r error("Rotation failed\n")) b=if(axlIsDBIDType(r) then r else car(r)) b=axlDBRefreshId(b)
  fprintf(f "ROTATE origin=(0 -2) actual=%L angle=%L\n" b->xy b->rotation)
  r=axlTransformObject(c ?mirror t ?origin c->xy ?allOrNone t)
  unless(r error("Mirror failed\n")) c=if(axlIsDBIDType(r) then r else car(r)) c=axlDBRefreshId(c)
  fprintf(f "MIRROR origin=(10 -2) actual=%L mirrored=%L\n" c->xy c->isMirrored)
  l5Dump(list(a b c) strcat(base "/logs/create02/after"))
  oldId=a
  saved=axlSaveDesign(?design strcat(base "/lesson05_instances.brd") ?noMru t ?noConfirm t)
  unless(saved error("Save failed\n"))
  fprintf(f "saved=%L old_symbol_dbid_is_type_after_save=%L\n" saved axlIsDBIDType(oldId))
  ; Reacquire; never dereference old dbids after save.
  syms=axlDBGetDesign()->symbols
  l5Dump(syms strcat(base "/logs/create02/after_save"))
  fprintf(f "symbols_after_save=%d\nLESSON05 COMPLETE\n" length(syms))
  close(f)
  t
 )
)
procedure(l5Read(base)
 let((f d)
  d=axlDBGetDesign()
  f=outfile(strcat(base "/logs/reopen/summary.txt"))
  fprintf(f "LESSON05_READ START\nunits=%L symbols=%d drcs=%d drcState=%L\n" axlDBGetDesignUnits() length(d->symbols) length(d->drcs) d->drcState)
  l5Dump(d->symbols strcat(base "/logs/reopen"))
  fprintf(f "LESSON05_READ COMPLETE\n")
  close(f)
  t
 )
)
