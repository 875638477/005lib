; L60: one text on a copied board; never open a source fixture for mutation.
procedure(l60Connected(start)
 let((todo seen obj neighbors)
  todo=list(start) seen=nil
  while(todo obj=car(todo) todo=cdr(todo)
   unless(member(obj seen)
    seen=cons(obj seen) neighbors=axlDBGetConnect(obj t)
    when(member(obj->objType list("path" "cline" "line" "arc"))
     when(listp(car(neighbors)) neighbors=append(car(neighbors) cadr(neighbors))))
    foreach(n neighbors unless(member(n seen) todo=cons(n todo))))) seen))
procedure(l60Objects()
 let((objects)
  objects=nil
  foreach(n axlDBGetDesign()->nets foreach(b n->branches foreach(c b->children foreach(o l60Connected(c) unless(member(o objects) objects=cons(o objects))))))
  foreach(b axlDBGetLonelyBranches() foreach(c b->children foreach(o l60Connected(c) unless(member(o objects) objects=cons(o objects)))))
  foreach(parent objects when(member(parent->objType list("path" "cline"))
   foreach(segment parent->segments unless(member(segment objects) objects=cons(segment objects))))) objects))
procedure(l60Name(o) if(o && o->net then o->net->name else nil))
procedure(l60Geometry()
 let((d rows objects poly)
  d=axlDBGetDesign() rows=nil objects=nil
  rows=cons(sprintf(nil "UNITS %L" axlDBGetDesignUnits()) rows)
  rows=cons(sprintf(nil "LAYERS %L" axlSubclassRoute()) rows)
  foreach(c d->components
   rows=cons(sprintf(nil "COMP %L" list(c->name c->package c->deviceType)) rows)
   foreach(p c->pins rows=cons(sprintf(nil "LOGICAL_PIN %L" list(c->name p->number l60Name(p))) rows)))
  foreach(s d->symbols
   rows=cons(sprintf(nil "POSE %L" list(s->refdes s->name s->xy s->rotation s->isMirrored)) rows)
   foreach(p s->pins rows=cons(sprintf(nil "PHYSICAL_PIN %L" list(s->refdes p->number p->xy p->rotation p->name p->isMech l60Name(p))) rows)))
  foreach(n d->nets rows=cons(sprintf(nil "NET %L" list(n->name length(n->pins))) rows))
  objects=l60Objects()
  foreach(o objects
   when(equal(o->objType "line") && o->isEtch rows=cons(sprintf(nil "ETCH_LINE %L" list(l60Name(o) o->layer o->startEnd o->width if(o->thermal || (o->parent && o->parent->thermal) then t else nil))) rows))
   when(equal(o->objType "arc") && o->isEtch rows=cons(sprintf(nil "ETCH_ARC %L" list(l60Name(o) o->layer o->startEnd o->width o->bBox o->radius)) rows))
   when(equal(o->objType "via") rows=cons(sprintf(nil "VIA %L" list(l60Name(o) o->name o->xy o->definition->drillDiameter)) rows)))
  foreach(o axlDBGetShapes("ETCH") foreach(poly axlPolyFromDB(o)
   rows=cons(sprintf(nil "COPPER %L" list(o->layer l60Name(o) o->fill o->shapeIsBoundary o->fillOOD o->bBox poly->area poly->vertices mapcar(lambda((h) h->vertices) poly->holes))) rows)))
  sort(rows 'alphalessp)))
procedure(l60Read(out phase)
 let((f d pins texts total manual thermal parent)
  axlDBRefreshId(nil) d=axlDBGetDesign() pins=0 texts=nil
  foreach(c d->components pins=pins+length(c->pins))
  foreach(tx d->text when(equal(tx->text "L60_REPLAY") texts=cons(tx texts)))
  total=0 manual=0 thermal=0
  foreach(o l60Objects()
   when(member(o->objType list("line" "arc")) && o->isEtch
    parent=o->parent total=total+1
    if(o->thermal || (parent && parent->thermal) then thermal=thermal+1 else manual=manual+1)))
  f=outfile(strcat(out "/" phase "_summary.tsv"))
  fprintf(f "components\t%d\nlogicalPins\t%d\nnets\t%d\nunits\t%L\nlayers\t%L\nmarkerCount\t%d\n" length(d->components) pins length(d->nets) axlDBGetDesignUnits() axlSubclassRoute() length(texts))
  foreach(tx texts fprintf(f "MARKER\t%L\t%L\t%.8f\t%.8f\t%.8f\n" tx->text tx->layer car(tx->xy) cadr(tx->xy) tx->rotation))
  fprintf(f "etchSegments\t%d\nmanualSegments\t%d\nthermalSegments\t%d\nL60_NATIVE_READ_COMPLETE\n" total manual thermal) close(f)
  f=outfile(strcat(out "/" phase "_geometry.txt")) foreach(row l60Geometry() fprintf(f "%s\n" row)) close(f)
  unless(total==932 && manual==750 && thermal==182 error("L60 nonempty actual segment counts differ\n"))
  unless(length(d->components)==80 && pins==272 && length(d->nets)==69 error("L60 fixture counts differ\n"))
  unless(equal(axlSubclassRoute() list("TOP" "L2" "L3" "BOTTOM")) error("L60 physical layer order differs\n"))
  unless(equal(car(axlDBGetDesignUnits()) "millimeters") error("L60 expects native MM units\n"))
  if(equal(phase "before") then unless(null(texts) error("L60 marker already present\n"))
   else unless(length(texts)==1 && equal(car(texts)->layer "BOARD GEOMETRY/ASSEMBLY_NOTES") && abs(car(car(texts)->xy)-4.0)<0.00001 && abs(cadr(car(texts)->xy)-4.0)<0.00001 error("L60 marker missing or different\n"))) t))
procedure(l60Build(out savepath)
 let((f mark before after result orient tx)
  l60Read(out "before") before=l60Geometry() mark=axlDBTransactionStart()
  unless(mark error("L60 cannot start transaction\n"))
  result=errset(progn(
   orient=make_axlTextOrientation(?textBlock "2" ?rotation 0.0 ?mirrored nil ?justify "center")
   tx=axlDBCreateText("L60_REPLAY" 4:4 orient "BOARD GEOMETRY/ASSEMBLY_NOTES" nil)
   unless(tx error("L60 create marker failed\n"))
   after=l60Geometry() unless(equal(before after) error("L60 geometry changed; refuse save\n"))
   l60Read(out "memory") t) t)
  f=outfile(strcat(out "/build_result.txt"))
  if(result then axlDBTransactionCommit(mark)
   unless(axlSaveDesign(?design savepath ?noMru t ?noConfirm t) error("L60 SaveAs failed\n"))
   fprintf(f "L60_SAVED_NEW_BOARD\n%s\n" savepath)
   else axlDBTransactionRollback(mark) fprintf(f "L60_FAILED_ROLLED_BACK\n"))
  close(f) result))
