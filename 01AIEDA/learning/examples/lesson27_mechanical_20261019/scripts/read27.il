procedure(l27Read(out)
 let((f sf pf gf layers sym p ps obj poly box pad)
  deBoardRead(out)
  f=outfile(strcat(out "/mechanical_summary.txt"))
  sf=outfile(strcat(out "/symbols.tsv"))
  pf=outfile(strcat(out "/physical_pins.tsv"))
  gf=outfile(strcat(out "/mechanical_shapes.tsv"))
  fprintf(f "outline=%L\nkeepinPlace=%L\nkeepinRoute=%L\n" axlDBGetDesign()->designOutline axlDBGetDesign()->keepinPlace axlDBGetDesign()->keepinRoute)
  fprintf(sf "name\tx\ty\trotation\tmirrored\ttype\tpins\n")
  fprintf(pf "symbol\tpin\tx\ty\tmechanical\tpadstack\thole_type\tplating\tdiameter\tdrillx\tdrilly\tlayer\tregular\tbbox\n")
  foreach(sym axlDBGetDesign()->symbols
   fprintf(sf "%L\t%L\t%L\t%L\t%L\t%L\t%d\n" sym->name car(sym->xy) cadr(sym->xy) sym->rotation sym->isMirrored sym->symbolType length(sym->pins))
   foreach(p sym->pins
    ps=p->definition
    foreach(layer list("ETCH/TOP" "ETCH/BOTTOM")
     pad=axlDBGetPad(p layer "REGULAR")
     fprintf(pf "%L\t%L\t%L\t%L\t%L\t%L\t%L\t%L\t%L\t%L\t%L\t%L\t%L\t%L\n" sym->name p->number car(p->xy) cadr(p->xy) p->isMech p->name ps->holeType ps->plating ps->drillDiameter ps->drillSizeWidth ps->drillSizeHeight layer if(pad then pad->figureName else nil) if(pad then pad->bBox else nil)))))
  fprintf(gf "layer\tbox\tfilled\tprops\tvertices\n")
  foreach(layer list("BOARD GEOMETRY/DESIGN_OUTLINE" "ROUTE KEEPIN/ALL" "PACKAGE KEEPIN/ALL" "ROUTE KEEPOUT/ALL" "PACKAGE KEEPOUT/ALL" "PACKAGE KEEPOUT/TOP" "PACKAGE KEEPOUT/BOTTOM" "PACKAGE GEOMETRY/PLACE_BOUND_TOP")
   foreach(obj axlDBGetShapes(layer)
    poly=car(axlPolyFromDB(obj))
    fprintf(gf "%L\t%L\t%L\t%L\t%L\n" layer obj->bBox obj->fill axlDBGetProperties(obj nil) if(poly then poly->vertices else nil))))
  fprintf(f "drcState=%L\ndrcs=%d\nL27_READ COMPLETE\n" axlDBGetDesign()->drcState length(axlDBGetDesign()->drcs))
  foreach(obj list(f sf pf gf) close(obj)) t))

procedure(l27More(out)
 let((f tf objs obj mark r box)
 f=outfile(strcat(out "/keepin_challenge.txt"))
 tf=outfile(strcat(out "/all_texts.tsv"))
 fprintf(tf "layer\ttext\tx\ty\tparenttype\n")
 objs=axlExtractMap("C:/Program0/Cadence/SPB172/share/pcb/text/views/fgeo_bv.txt" nil)
 foreach(obj objs when(equal(obj->objType "text")
  fprintf(tf "%L\t%L\t%L\t%L\t%L\n" obj->layer obj->text car(obj->xy) cadr(obj->xy) obj->parent->objType)))
 mark=axlDBTransactionStart()
 r=axlDBCreatePath(axlPathStart(list(0.1:25 2:25) 0.2) "ETCH/TOP" "GND" nil)
 unless(r error("Route keepin test failed\n"))
 fprintf(f "KEEPIN_CHALLENGE_RETURN=%L\n" axlDRCUpdate(t))
 l27DumpDRC(f "KEEPIN")
 unless(axlDBTransactionRollback(mark) error("Keepin rollback failed\n"))
 fprintf(f "AFTER_RETURN=%L\n" axlDRCUpdate(t))
 l27DumpDRC(f "AFTER")
 fprintf(f "L27_MORE COMPLETE\n") close(f) close(tf) t))
