; Lesson27 real native mechanical constraints, isolated from source.
procedure(l27Setup()
 axlDBChangeDesignUnits("millimeters" 3)
 axlDBChangeDesignExtents(list(-20:-20 100:85))
 axlSetVariable("padpath" list("D:/001DIY/005lib/01AIEDA/learning/examples/lesson27_mechanical_20261019/library" "D:/001DIY/005lib/01AIEDA/learning/examples/de_15_26_20261019/library"))
 axlSetVariable("psmpath" list("D:/001DIY/005lib/01AIEDA/learning/examples/lesson27_mechanical_20261019/library" "D:/001DIY/005lib/01AIEDA/learning/examples/de_15_26_20261019/library")))
procedure(l27Poly(points layer filled)
 let((r)
  r=axlDBCreateShape(axlPathStart(points 0.0) filled layer nil nil)
  unless(r error("Shape failed: %s\n" layer))
  car(r)))
procedure(l27Package(base out)
 let((f b style)
  l27Setup()
  f=outfile(strcat(out "/package.txt"))
  unless(axlDBCreatePin("eda_l07c_npth_200_null" 0:0 nil 0) error("Hole pin failed\n"))
  b=car(axlDBCreateShape(axlPathStartCircle(list(0:0 1.0) 0.0) t "PACKAGE GEOMETRY/PLACE_BOUND_TOP" nil nil))
  unless(b error("Mount bound failed\n"))
  axlDBAddProp(list(b) list("PACKAGE_HEIGHT_MAX" "1 MM"))
  axlDBCreateCircle(list(0:0 1.0) 0.05 "PACKAGE GEOMETRY/ASSEMBLY_TOP" nil)
  style=make_axlTextOrientation(?textBlock 1 ?rotation 0.0 ?mirrored nil ?justify "center")
  foreach(layer list("REF DES/SILKSCREEN_TOP" "REF DES/ASSEMBLY_TOP")
   unless(axlDBCreateText("H*" 0:0 style layer nil) error("Hole refdes text failed\n")))
  unless(axlDBCreateText("VALUE" 0:0 style "COMPONENT VALUE/ASSEMBLY_TOP" nil) error("Hole value failed\n"))
  unless(axlSaveDesign(?design strcat(base "/library/l27_npth_d200.dra") ?noMru t ?noConfirm t) error("Hole save failed\n"))
  unless(axlCompileSymbol(?symbol strcat(base "/library/l27_npth_d200")) error("Hole compile failed\n"))
  fprintf(f "L27_PACKAGE COMPLETE\n") close(f) t))
procedure(l27DumpDRC(f label)
 fprintf(f "%s count=%d state=%L\n" label length(axlDBGetDesign()->drcs) axlDBGetDesign()->drcState)
 foreach(d axlDBGetDesign()->drcs fprintf(f "%s_DRC %L\n" label d->??)))
procedure(l27Create(base out)
 let((f r b mark result drc sym style ko shape)
  l27Setup()
  f=outfile(strcat(out "/create.txt"))
  fprintf(f "SOURCE %s components=%d nets=%d\n" axlCurrentDesign() length(axlDBGetDesign()->components) length(axlDBGetDesign()->nets))
  unless(length(axlDBGetDesign()->components)==80 error("Source count failed\n"))
  ; Actual recognized design outline, counterclockwise, 2mm corner chamfers.
  b=l27Poly(list(2:0 78:0 80:2 80:58 78:60 2:60 0:58 0:2 2:0) "BOARD GEOMETRY/DESIGN_OUTLINE" nil)
  fprintf(f "OUTLINE_CREATED=%L ROOT_OUTLINE=%L\n" b axlDBGetDesign()->designOutline)
  unless(axlDBGetDesign()->designOutline error("Design outline not recognized\n"))
  l27Poly(list(2.207:0.5 77.793:0.5 79.5:2.207 79.5:57.793 77.793:59.5 2.207:59.5 0.5:57.793 0.5:2.207 2.207:0.5) "ROUTE KEEPIN/ALL" nil)
  ; Local J2 courtyard allowance 0.5mm beyond the PCB front edge.
  l27Poly(list(2.207:0.5 34.5:0.5 34.5:-0.5 45.5:-0.5 45.5:0.5 77.793:0.5 79.5:2.207 79.5:57.793 77.793:59.5 2.207:59.5 0.5:57.793 0.5:2.207 2.207:0.5) "PACKAGE KEEPIN/ALL" nil)
  result=axlDBCreateSymbol("J2" 40:3.675 nil 0)
  unless(result error("J2 placement failed\n"))
  foreach(p list(5:5 75:5 75:55 5:55)
   result=axlDBCreateSymbol(list("l27_npth_d200" "PACKAGE") p nil 0)
   unless(result error("Mount placement failed\n"))
   foreach(layer list("ROUTE KEEPOUT/ALL" "PACKAGE KEEPOUT/ALL")
    unless(axlDBCreateShape(axlPathStartCircle(list(p 2.5) 0.0) t layer nil nil) error("Hardware keepout failed\n"))))
  l27Poly(list(34:-12 46:-12 46:0 34:0 34:-12) "PACKAGE KEEPOUT/TOP" t)
  l27Poly(list(34:-12 46:-12 46:0 34:0 34:-12) "PACKAGE KEEPOUT/BOTTOM" t)
  ; Occupied height from 2mm to infinity means parts <=2mm may fit below it.
  ko=l27Poly(list(10:42 30:42 30:52 10:52 10:42) "PACKAGE KEEPOUT/TOP" t)
  unless(axlDBAddProp(list(ko) list("PACKAGE_HEIGHT_MIN" "2 MM" "PACKAGE_HEIGHT_MAX" "999 MM")) error("Height zone failed\n"))
  foreach(layer list("BOARD GEOMETRY/USER_MECH_DATUM" "BOARD GEOMETRY/USER_MECH_DIMENSIONS")
   axlLayerCreateNonConductor(layer))
  style=make_axlTextOrientation(?textBlock 1 ?rotation 0.0 ?mirrored nil ?justify "center")
  axlDBCreateLine(list(-3:0 3:0) 0.05 "BOARD GEOMETRY/USER_MECH_DATUM" nil nil)
  axlDBCreateLine(list(0:-3 0:3) 0.05 "BOARD GEOMETRY/USER_MECH_DATUM" nil nil)
  axlDBCreateText("DATUM A=(0,0); TOP +Z; UNITS mm" 40:76 style "BOARD GEOMETRY/USER_MECH_DIMENSIONS" nil)
  axlDBCreateText("80 x 60; C2 x 4; NPTH D2 @ (5,5),(75,5),(75,55),(5,55)" 40:72 style "BOARD GEOMETRY/USER_MECH_DIMENSIONS" nil)
  axlDBCreateText("J2 EDGE y=0; OPENING -Y; INSERTION +Y; H<=3.46" 40:68 style "BOARD GEOMETRY/USER_MECH_DIMENSIONS" nil)
  axlDBCreateText("TOP LOW PROFILE Z<=2; x10..30 y42..52" 20:54 style "BOARD GEOMETRY/USER_MECH_DIMENSIONS" nil)
  axlDBCreateLine(list(0:63 80:63) 0.05 "BOARD GEOMETRY/USER_MECH_DIMENSIONS" nil nil)
  axlDBCreateText("80.000" 40:64 style "BOARD GEOMETRY/USER_MECH_DIMENSIONS" nil)
  axlDBCreateLine(list(83:0 83:60) 0.05 "BOARD GEOMETRY/USER_MECH_DIMENSIONS" nil nil)
  fprintf(f "DESIGN_MODES_BEFORE=%L\n" axlCNSDesignModeGet(nil))
  axlCNSDesignModeSet('Package_to_Place_Keepin_Spacing 'on)
  axlCNSDesignModeSet('Package_to_Place_Keepout_Spacing 'on)
  fprintf(f "BASE_DRC_RETURN=%L\n" axlDRCUpdate(t)) l27DumpDRC(f "BASE")
  mark=axlDBTransactionStart()
  result=axlDBCreatePath(axlPathStart(list(3:5 7:5) 0.2) "ETCH/TOP" "GND" nil)
  unless(result error("Route challenge creation failed\n"))
  fprintf(f "ROUTE_CHALLENGE_RETURN=%L\n" axlDRCUpdate(t)) l27DumpDRC(f "ROUTE")
  axlDBTransactionRollback(mark)
  axlDRCUpdate(t)
  mark=axlDBTransactionStart()
  sym=axlDBFindByName('refdes "J2")->symbol
  result=axlTransformObject(sym ?move -20:43.325)
  unless(result error("Height challenge transform failed\n"))
  fprintf(f "HEIGHT_CHALLENGE_RETURN=%L\n" axlDRCUpdate(t)) l27DumpDRC(f "HEIGHT")
  axlDBTransactionRollback(mark)
  axlDRCUpdate(t)
  mark=axlDBTransactionStart()
  sym=axlDBFindByName('refdes "J2")->symbol
  result=axlTransformObject(sym ?move -35:1.325)
  unless(result error("Placement challenge transform failed\n"))
  fprintf(f "PLACE_CHALLENGE_RETURN=%L\n" axlDRCUpdate(t)) l27DumpDRC(f "PLACE")
  axlDBTransactionRollback(mark)
  fprintf(f "FINAL_DRC_RETURN=%L\n" axlDRCUpdate(t)) l27DumpDRC(f "FINAL")
  unless(axlSaveDesign(?design strcat(base "/F27_MECHANICAL.brd") ?noMru t ?noConfirm t) error("Board save failed\n"))
  fprintf(f "L27_CREATE COMPLETE\n") close(f) t))
