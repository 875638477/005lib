procedure(l6FirstDbid(r)
 if(axlIsDBIDType(r) then r else if(r && listp(r) then l6FirstDbid(car(r)) else nil))
)
; Lesson06 native database operations. No GUI input and no global configuration writes.
procedure(l6Shape() car(axlDBGetShapes("PACKAGE GEOMETRY/ASSEMBLY_TOP")))
procedure(l6State(f label)
 let((s box)
  axlDBRefreshId(nil)
  s=l6Shape()
  unless(s error("Target shape missing\n"))
  box=s->bBox
  fprintf(f "%s\t%.9f\t%.9f\t%.9f\t%.9f\n" label car(car(box)) cadr(car(box)) car(cadr(box)) cadr(cadr(box)))
))
procedure(l6Geometry(outPath)
 let((f objs o segs s polys p box)
  f=outfile(outPath)
  fprintf(f "type\tlayer\tstart_end\twidth\tbbox\tpoly_bbox\tvertices\n")
  objs=axlExtractMap("C:/Program0/Cadence/SPB172/share/pcb/text/views/fgeo_bv.txt" nil)
  foreach(o objs
   when(member(o->objType list("line" "path"))
    segs=if(equal(o->objType "path") then o->segments else list(o))
    foreach(s segs
     polys=axlPolyFromDB(s)
     p=car(polys)
     fprintf(f "%L\t%L\t%L\t%.9f\t%L\t%L\t%L\n" s->objType s->layer s->startEnd s->width s->bBox
      if(p then p->bBox else nil) if(p then p->vertices else nil)))
   )
  )
  close(f)
  t
 )
)
procedure(l6Create(base)
 let((f states grid oldXO oldYO oldXG oldYG oldVis oldEn oldOn mark r saved x tx tf texts style)
  unless(equal(axlCurrentDesign() "lesson06_operations") && equal(axlDesignType(t) "BOARD") error("Wrong board\n"))
  f=outfile(strcat(base "/logs/create03/operations.txt"))
  states=outfile(strcat(base "/logs/create03/states.tsv"))
  fprintf(states "state\tminx\tminy\tmaxx\tmaxy\n")
  fprintf(f "LESSON06 START\n")
  axlDBChangeDesignUnits("millimeters" 3)
  unless(axlDBChangeDesignExtents(list(-20.0:-20.0 30.0:20.0)) error("Extents failed\n"))
  r=axlDBCreateRectangle(list(5.0:5.0 7.0:7.0) t "PACKAGE GEOMETRY/ASSEMBLY_TOP" nil nil)
  unless(r error("Shape creation failed\n"))
  style=make_axlTextOrientation(?textBlock "1" ?rotation 0 ?mirrored nil ?justify "center")
  unless(axlDBCreateText("TARGET" 6:6 style "PACKAGE GEOMETRY/ASSEMBLY_TOP" nil) error("Text creation failed\n"))
  l6State(states "INITIAL")
  grid=axlDBGridGet("non-etch")
  oldXO=grid->xOrigin oldYO=grid->yOrigin oldXG=grid->xGrids oldYG=grid->yGrids
  fprintf(f "grid_original=(%L %L %L %L)\n" oldXO oldYO oldXG oldYG)
  grid->xOrigin=0.0 grid->yOrigin=0.0 grid->xGrids=0.05 grid->yGrids=0.05
  unless(axlDBGridSet(grid) error("Grid set failed\n"))
  grid=axlDBGridGet("non-etch")
  fprintf(f "grid_test=(%L %L %L %L)\n" grid->xOrigin grid->yOrigin grid->xGrids grid->yGrids)
  fprintf(f "filter_initial_nil=%L buttons=%L\n" axlGetFindFilter(nil) axlGetFindFilter(t))
  axlSetFindFilter(?enabled list("noall" "lines" "shapes" "text") ?onButtons list("noall" "lines"))
  oldVis=axlVisibleGet() oldEn=axlGetFindFilter(nil) oldOn=axlGetFindFilter(t)
  fprintf(f "filter_original_enabled=%L buttons=%L\n" oldEn oldOn)
  axlVisibleDesign(nil)
  axlVisibleLayer("PACKAGE GEOMETRY/ASSEMBLY_TOP" t)
  axlSetFindFilter(?enabled list("noall" "shapes" "text") ?onButtons list("noall" "shapes"))
  fprintf(f "filter_probe_nil=%L probe_t=%L\n" axlGetFindFilter(nil) axlGetFindFilter(t))
  axlClearSelSet()
  r=axlSingleSelectBox(list(4:4 8:8))
  fprintf(f "selection_result=%L count=%d types=%L\n" r length(axlGetSelSet()) axlGetSelSet()~>objType)
  unless(length(axlGetSelSet())==1 && equal(car(axlGetSelSet())->objType "shape") error("Filtered selection mismatch\n"))
  axlClearSelSet()
  axlVisibleSet(oldVis)
  axlSetFindFilter(?enabled append(list("noall") oldEn) ?onButtons append(list("noall") oldOn))
  fprintf(f "visibility_restored=%L filter_enabled_restored=%L filter_buttons_restored=%L\n"
   equal(oldVis axlVisibleGet()) equal(oldEn axlGetFindFilter(nil)) equal(oldOn axlGetFindFilter(t)))
  mark=axlDBTransactionStart()
  unless(mark error("Transaction start failed\n"))
  unless(axlTransformObject(l6Shape() ?move 2.0:-1.0) error("Transaction move failed\n"))
  l6State(states "MOVED")
  unless(axlDBTransactionMark(mark) error("Mark failed\n"))
  unless(axlTransformObject(l6Shape() ?angle 90.0 ?origin 7.0:4.0) error("Transaction rotate failed\n"))
  l6State(states "ROTATED")
  unless(axlDBTransactionOops(mark) error("Oops failed\n"))
  l6State(states "OOPS")
  unless(axlDBTransactionRollback(mark) error("Rollback failed\n"))
  l6State(states "ROLLBACK")
  mark=axlDBTransactionStart()
  unless(axlTransformObject(l6Shape() ?move -1.0:2.0) error("Commit move failed\n"))
  unless(axlDBTransactionCommit(mark) error("Commit failed\n"))
  l6State(states "COMMIT")
  ; GridSet is not undoable: explicitly restore, outside transaction assumptions.
  grid=axlDBGridGet("non-etch")
  grid->xOrigin=oldXO grid->yOrigin=oldYO grid->xGrids=oldXG grid->yGrids=oldYG
  unless(axlDBGridSet(grid) error("Grid restore failed\n"))
  grid=axlDBGridGet("non-etch")
  fprintf(f "grid_restored=%L\n" equal(list(oldXO oldYO oldXG oldYG) list(grid->xOrigin grid->yOrigin grid->xGrids grid->yGrids)))
  ; Input quantization is measured, not assumed to match the display grid.
  tf=outfile(strcat(base "/logs/create03/quantization.tsv"))
  fprintf(tf "input_x\tactual_x\tactual_y\n")
  foreach(x list(-0.0006 -0.0005 -0.0004 0.0004 0.0005 0.0006 10.0004 10.0005 10.0006)
   r=axlDBCreateText("Q" list(x -8.0) style "PACKAGE GEOMETRY/DISPLAY_TOP" nil)
   unless(r error("Quantization probe failed\n"))
   tx=l6FirstDbid(r)
   fprintf(tf "%.9f\t%.9f\t%.9f\n" x car(tx->xy) cadr(tx->xy)))
  close(tf)
  unless(axlDBCreateLine(list(1.0:1.0 4.0:1.0) 0.101 "PACKAGE GEOMETRY/DISPLAY_TOP" nil nil) error("Odd DBU width line failed\n"))
  l6Geometry(strcat(base "/logs/create03/geometry.tsv"))
  saved=axlSaveDesign(?design strcat(base "/lesson06_operations.brd") ?noMru t ?noConfirm t)
  unless(saved error("Save failed\n"))
  l6State(states "AFTER_SAVE")
  l6Geometry(strcat(base "/logs/create03/geometry_after_save.tsv"))
  fprintf(f "saved=%L\nLESSON06 COMPLETE_NATIVE_SUBSET\n" saved)
  close(states) close(f)
  t
 )
)
procedure(l6Read(base)
 let((f d)
  f=outfile(strcat(base "/logs/reopen/states.tsv"))
  fprintf(f "state\tminx\tminy\tmaxx\tmaxy\n")
  l6State(f "REOPEN")
  close(f)
  l6Geometry(strcat(base "/logs/reopen/geometry.tsv"))
  d=axlDBGetDesign()
  f=outfile(strcat(base "/logs/reopen/summary.txt"))
  fprintf(f "LESSON06_READ COMPLETE\nunits=%L drcs=%d drcState=%L\n" axlDBGetDesignUnits() length(d->drcs) d->drcState)
  close(f)
  t
 )
)
