; QMI8610 Rev A; datasheet PDF p8/p9/p79. New isolated drawing only.
procedure(qmiCreate(libDir reportPath)
  let((report units padRecord textStyle numberStyle textBlock numberBlock pinText result bound saved compiled)
    report = outfile(reportPath)
    unless(report error("Cannot open create report\n"))
    fprintf(report "QMI8610_CREATE START\ndesign=%L type=%L\n" axlCurrentDesign() axlDesignType(t))
    unless(equal(axlCurrentDesign() "qmi8610_lga16_3d3_p0d5") error("Unexpected drawing name\n"))
    unless(equal(axlDesignType(t) "PACKAGE") || equal(axlDesignType(t) "package") error("Requires package drawing\n"))
    unless(length(axlDBGetDesign()->pins) == 0 error("Requires empty drawing\n"))
    axlDBChangeDesignUnits("millimeters" 3)
    units = axlDBGetDesignUnits()
    unless(equal(units list("millimeters" 3)) error("Unexpected units\n"))
    unless(axlDBChangeDesignExtents(list(-10.0:-10.0 10.0:10.0)) error("Cannot set extents\n"))
    axlSetVariable("padpath" list(libDir))
    axlSetVariable("psmpath" list(libDir))
    padRecord = axlLoadPadstack("qmi8610_smd061x032_m05_p100")
    unless(padRecord error("Cannot load padstack\n"))
    textBlock = axlDBTextBlockCreate(1 ?width 0.45 ?height 0.60 ?lineSpace 0.30 ?charSpace 0.08 ?photoWidth 0.10)
    numberBlock = axlDBTextBlockCreate(1 ?width 0.225 ?height 0.30 ?lineSpace 0.15 ?charSpace 0.04 ?photoWidth 0.05)
    unless(textBlock && numberBlock error("Cannot create text blocks\n"))
    textStyle = make_axlTextOrientation(?textBlock sprintf(nil "%d" textBlock) ?rotation 0.0 ?mirrored nil ?justify "center")
    numberStyle = make_axlTextOrientation(?textBlock sprintf(nil "%d" numberBlock) ?rotation 0.0 ?mirrored nil ?justify "center")
    pinText = make_axlPinText(?number "1" ?offset 0:0 ?text numberStyle)
    result = axlDBCreatePin(padRecord -1.395:0.750 pinText 0.0)
    unless(result error("Cannot create pin 1\n"))
    fprintf(report "pin=%L xy=%L rotation=%L drc=%L\n" car(result)->number car(result)->xy car(result)->rotation cadr(result))
    pinText = make_axlPinText(?number "2" ?offset 0:0 ?text numberStyle)
    result = axlDBCreatePin(padRecord -1.395:0.250 pinText 0.0)
    unless(result error("Cannot create pin 2\n"))
    fprintf(report "pin=%L xy=%L rotation=%L drc=%L\n" car(result)->number car(result)->xy car(result)->rotation cadr(result))
    pinText = make_axlPinText(?number "3" ?offset 0:0 ?text numberStyle)
    result = axlDBCreatePin(padRecord -1.395:-0.250 pinText 0.0)
    unless(result error("Cannot create pin 3\n"))
    fprintf(report "pin=%L xy=%L rotation=%L drc=%L\n" car(result)->number car(result)->xy car(result)->rotation cadr(result))
    pinText = make_axlPinText(?number "4" ?offset 0:0 ?text numberStyle)
    result = axlDBCreatePin(padRecord -1.395:-0.750 pinText 0.0)
    unless(result error("Cannot create pin 4\n"))
    fprintf(report "pin=%L xy=%L rotation=%L drc=%L\n" car(result)->number car(result)->xy car(result)->rotation cadr(result))
    pinText = make_axlPinText(?number "5" ?offset 0:0 ?text numberStyle)
    result = axlDBCreatePin(padRecord -0.750:-1.395 pinText 90.0)
    unless(result error("Cannot create pin 5\n"))
    fprintf(report "pin=%L xy=%L rotation=%L drc=%L\n" car(result)->number car(result)->xy car(result)->rotation cadr(result))
    pinText = make_axlPinText(?number "6" ?offset 0:0 ?text numberStyle)
    result = axlDBCreatePin(padRecord -0.250:-1.395 pinText 90.0)
    unless(result error("Cannot create pin 6\n"))
    fprintf(report "pin=%L xy=%L rotation=%L drc=%L\n" car(result)->number car(result)->xy car(result)->rotation cadr(result))
    pinText = make_axlPinText(?number "7" ?offset 0:0 ?text numberStyle)
    result = axlDBCreatePin(padRecord 0.250:-1.395 pinText 90.0)
    unless(result error("Cannot create pin 7\n"))
    fprintf(report "pin=%L xy=%L rotation=%L drc=%L\n" car(result)->number car(result)->xy car(result)->rotation cadr(result))
    pinText = make_axlPinText(?number "8" ?offset 0:0 ?text numberStyle)
    result = axlDBCreatePin(padRecord 0.750:-1.395 pinText 90.0)
    unless(result error("Cannot create pin 8\n"))
    fprintf(report "pin=%L xy=%L rotation=%L drc=%L\n" car(result)->number car(result)->xy car(result)->rotation cadr(result))
    pinText = make_axlPinText(?number "9" ?offset 0:0 ?text numberStyle)
    result = axlDBCreatePin(padRecord 1.395:-0.750 pinText 0.0)
    unless(result error("Cannot create pin 9\n"))
    fprintf(report "pin=%L xy=%L rotation=%L drc=%L\n" car(result)->number car(result)->xy car(result)->rotation cadr(result))
    pinText = make_axlPinText(?number "10" ?offset 0:0 ?text numberStyle)
    result = axlDBCreatePin(padRecord 1.395:-0.250 pinText 0.0)
    unless(result error("Cannot create pin 10\n"))
    fprintf(report "pin=%L xy=%L rotation=%L drc=%L\n" car(result)->number car(result)->xy car(result)->rotation cadr(result))
    pinText = make_axlPinText(?number "11" ?offset 0:0 ?text numberStyle)
    result = axlDBCreatePin(padRecord 1.395:0.250 pinText 0.0)
    unless(result error("Cannot create pin 11\n"))
    fprintf(report "pin=%L xy=%L rotation=%L drc=%L\n" car(result)->number car(result)->xy car(result)->rotation cadr(result))
    pinText = make_axlPinText(?number "12" ?offset 0:0 ?text numberStyle)
    result = axlDBCreatePin(padRecord 1.395:0.750 pinText 0.0)
    unless(result error("Cannot create pin 12\n"))
    fprintf(report "pin=%L xy=%L rotation=%L drc=%L\n" car(result)->number car(result)->xy car(result)->rotation cadr(result))
    pinText = make_axlPinText(?number "13" ?offset 0:0 ?text numberStyle)
    result = axlDBCreatePin(padRecord 0.750:1.395 pinText 90.0)
    unless(result error("Cannot create pin 13\n"))
    fprintf(report "pin=%L xy=%L rotation=%L drc=%L\n" car(result)->number car(result)->xy car(result)->rotation cadr(result))
    pinText = make_axlPinText(?number "14" ?offset 0:0 ?text numberStyle)
    result = axlDBCreatePin(padRecord 0.250:1.395 pinText 90.0)
    unless(result error("Cannot create pin 14\n"))
    fprintf(report "pin=%L xy=%L rotation=%L drc=%L\n" car(result)->number car(result)->xy car(result)->rotation cadr(result))
    pinText = make_axlPinText(?number "15" ?offset 0:0 ?text numberStyle)
    result = axlDBCreatePin(padRecord -0.250:1.395 pinText 90.0)
    unless(result error("Cannot create pin 15\n"))
    fprintf(report "pin=%L xy=%L rotation=%L drc=%L\n" car(result)->number car(result)->xy car(result)->rotation cadr(result))
    pinText = make_axlPinText(?number "16" ?offset 0:0 ?text numberStyle)
    result = axlDBCreatePin(padRecord -0.750:1.395 pinText 90.0)
    unless(result error("Cannot create pin 16\n"))
    fprintf(report "pin=%L xy=%L rotation=%L drc=%L\n" car(result)->number car(result)->xy car(result)->rotation cadr(result))
    result = axlDBCreateLine(list(-1.150:-1.950 -1.950:-1.950 -1.950:-1.150) 0.1 "PACKAGE GEOMETRY/SILKSCREEN_TOP" nil nil)
    unless(result error("Cannot create PACKAGE GEOMETRY/SILKSCREEN_TOP path\n"))
    result = axlDBCreateLine(list(-1.150:1.950 -1.950:1.950 -1.950:1.150) 0.1 "PACKAGE GEOMETRY/SILKSCREEN_TOP" nil nil)
    unless(result error("Cannot create PACKAGE GEOMETRY/SILKSCREEN_TOP path\n"))
    result = axlDBCreateLine(list(1.150:-1.950 1.950:-1.950 1.950:-1.150) 0.1 "PACKAGE GEOMETRY/SILKSCREEN_TOP" nil nil)
    unless(result error("Cannot create PACKAGE GEOMETRY/SILKSCREEN_TOP path\n"))
    result = axlDBCreateLine(list(1.150:1.950 1.950:1.950 1.950:1.150) 0.1 "PACKAGE GEOMETRY/SILKSCREEN_TOP" nil nil)
    unless(result error("Cannot create PACKAGE GEOMETRY/SILKSCREEN_TOP path\n"))
    result = axlDBCreateLine(list(-1.750:1.750 -1.550:1.750 -1.750:1.550 -1.750:1.750) 0.1 "PACKAGE GEOMETRY/SILKSCREEN_TOP" nil nil)
    unless(result error("Cannot create PACKAGE GEOMETRY/SILKSCREEN_TOP path\n"))
    result = axlDBCreateLine(list(-1.650:-1.650 1.650:-1.650 1.650:1.650 -1.650:1.650 -1.650:-1.650) 0.05 "PACKAGE GEOMETRY/ASSEMBLY_TOP" nil nil)
    unless(result error("Cannot create PACKAGE GEOMETRY/ASSEMBLY_TOP path\n"))
    result = axlDBCreateLine(list(-1.400:1.400 -1.200:1.400 -1.400:1.200 -1.400:1.400) 0.05 "PACKAGE GEOMETRY/ASSEMBLY_TOP" nil nil)
    unless(result error("Cannot create PACKAGE GEOMETRY/ASSEMBLY_TOP path\n"))
    result = axlDBCreateRectangle(list(-2.0:-2.0 2.0:2.0) t "PACKAGE GEOMETRY/PLACE_BOUND_TOP" nil nil)
    unless(result error("Cannot create place bound\n"))
    bound = car(result)
    unless(axlDBAddProp(list(bound) list("PACKAGE_HEIGHT_MAX" "1 MM")) error("Cannot set height\n"))
    fprintf(report "height=%L\n" axlDBGetProperties(bound nil))
    result = axlDBCreateText("U*" 0:0 textStyle "REF DES/SILKSCREEN_TOP" nil)
    unless(result error("Cannot create REF DES/SILKSCREEN_TOP text\n"))
    result = axlDBCreateText("U*" 0:0 textStyle "REF DES/ASSEMBLY_TOP" nil)
    unless(result error("Cannot create REF DES/ASSEMBLY_TOP text\n"))
    result = axlDBCreateText("VALUE" 0:0 textStyle "COMPONENT VALUE/ASSEMBLY_TOP" nil)
    unless(result error("Cannot create COMPONENT VALUE/ASSEMBLY_TOP text\n"))
    saved = axlSaveDesign(?design strcat(libDir "/qmi8610_lga16_3d3_p0d5.dra") ?noMru t ?noConfirm t)
    unless(saved error("Cannot save package\n"))
    fprintf(report "pins_after_save=%d\n" length(axlDBGetDesign()->pins))
    unless(length(axlDBGetDesign()->pins) == 16 error("Expected 16 saved peripheral pins\n"))
    compiled = axlCompileSymbol(?symbol strcat(libDir "/qmi8610_lga16_3d3_p0d5"))
    unless(compiled error("Cannot compile package\n"))
    fprintf(report "saved=%L compiled=%L\nQMI8610_CREATE COMPLETE\n" saved compiled)
    close(report)
    t
  )
)
