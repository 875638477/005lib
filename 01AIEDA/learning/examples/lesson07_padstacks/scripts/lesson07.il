; Isolated Lesson07. Only named teaching coupon/board may be edited.
procedure(l7Setup(libDir)
  axlDBChangeDesignUnits("millimeters" 3)
  unless(equal(axlDBGetDesignUnits() list("millimeters" 3)) error("Wrong units\n"))
  unless(axlDBChangeDesignExtents(list(-20.0:-15.0 20.0:15.0)) error("Extents failed\n"))
  axlSetVariable("padpath" list(libDir))
  axlSetVariable("psmpath" list(libDir))
)
procedure(l7CreatePackage(libDir outDir)
  let((f style text p result bound saved compiled cases c)
    unless(equal(axlCurrentDesign() "eda_l07_padstack_coupon") error("Wrong package name\n"))
    unless(length(axlDBGetDesign()->pins)==0 error("Not empty\n"))
    l7Setup(libDir)
    f=outfile(strcat(outDir "/create.txt"))
    fprintf(f "L07_PACKAGE_CREATE START\nunits=%L\n" axlDBGetDesignUnits())
    style=make_axlTextOrientation(?textBlock "2" ?rotation 0.0 ?mirrored nil ?justify "center")
    cases=list(
      list("eda_l07_pth_080_c160" -5.0:4.0 "1" 0.0)
      list("eda_l07_pth_080_c160" 5.0:4.0 "2" 90.0)
      list("eda_l07_npth_200_ring" -5.0:0.0 nil 0.0)
      list("eda_l07_npth_200_ring" 5.0:0.0 nil 90.0)
      list("eda_l07_plated_slot_200x100" -5.0:-4.0 "5" 0.0)
      list("eda_l07_plated_slot_200x100" 5.0:-4.0 "6" 90.0))
    foreach(c cases
      p=axlLoadPadstack(car(c))
      unless(p error("Padstack load failed\n"))
      text=nil
      when(caddr(c) text=make_axlPinText(?number caddr(c) ?offset 0:0 ?text style))
      result=axlDBCreatePin(p cadr(c) text cadddr(c))
      unless(result error("Pin create failed\n"))
      fprintf(f "pin=%L xy=%L rotation=%L mechanical=%L drc=%L\n"
        car(result)->number car(result)->xy car(result)->rotation car(result)->isMech cadr(result)))
    fprintf(f "root_pin_count_before_save=%d (cache observation only)\n" length(axlDBGetDesign()->pins))
    result=axlDBCreateRectangle(list(-7.0:-6.0 7.0:6.0) t "PACKAGE GEOMETRY/PLACE_BOUND_TOP" nil nil)
    unless(result error("Bound failed\n"))
    bound=car(result)
    unless(axlDBAddProp(list(bound) list("PACKAGE_HEIGHT_MAX" "1 MM")) error("Height failed\n"))
    foreach(layer list("REF DES/SILKSCREEN_TOP" "REF DES/ASSEMBLY_TOP")
      unless(axlDBCreateText("U*" 0:0 style layer nil) error("Refdes failed\n")))
    unless(axlDBCreateText("VALUE" 0:0 style "COMPONENT VALUE/ASSEMBLY_TOP" nil) error("Value failed\n"))
    saved=axlSaveDesign(?design strcat(libDir "/eda_l07_padstack_coupon.dra") ?noMru t ?noConfirm t)
    unless(saved error("Save failed\n"))
    compiled=axlCompileSymbol(?symbol strcat(libDir "/eda_l07_padstack_coupon"))
    unless(compiled error("Compile failed\n"))
    fprintf(f "saved=%L compiled=%L\nL07_PACKAGE_CREATE COMPLETE\n" saved compiled)
    close(f)
    t))
procedure(l7CreateBoard(libDir outDir)
  let((f xs definition result saved)
    unless(equal(axlCurrentDesign() "eda_l07_mapping_4layer") error("Wrong board name\n"))
    unless(length(axlDBGetDesign()->symbols)==0 error("Not an empty board\n"))
    l7Setup(libDir)
    f=outfile(strcat(outDir "/create.txt"))
    fprintf(f "L07_BOARD_CREATE START\n")
    foreach(name list("L2" "L3")
      definition=axlXSectionModify(?name name ?layerType "CONDUCTOR" ?material "COPPER" ?thickness 0.035)
      xs=axlXSectionCreate(nil 'bottom definition)
      unless(xs error("Cannot add conductor layer\n"))
      definition=axlXSectionModify(?layerType "DIELECTRIC" ?material "FR-4" ?thickness 0.4)
      xs=axlXSectionCreate(nil 'bottom definition)
      unless(xs error("Cannot add dielectric layer\n")))
    foreach(xs axlXSectionGet(nil 'all)
      when(equal(xs->layerType "DIELECTRIC")
        unless(axlXSectionSet(xs axlXSectionModify(?thickness 0.4)) error("Cannot set dielectric\n"))))
    result=axlDBCreateSymbol(list("eda_l07_padstack_coupon" "PACKAGE") 0:0 nil 0.0)
    unless(result error("Cannot place isolated package\n"))
    ; Fresh object pin lists may be cached before save; reopened readback is authoritative.
    fprintf(f "symbol=%L pins=%d drc=%L\n" car(result)->name length(car(result)->pins) cadr(result))
    saved=axlSaveDesign(?design strcat(libDir "/eda_l07_mapping_4layer.brd") ?noMru t ?noConfirm t)
    unless(saved error("Cannot save board\n"))
    fprintf(f "saved=%L\nL07_BOARD_CREATE COMPLETE\n" saved)
    close(f)
    t))
procedure(l7AllPins()
  let((pins sym)
    pins=axlDBGetDesign()->pins
    unless(pins
      foreach(sym axlDBGetDesign()->symbols pins=append(pins sym->pins)))
    pins))
procedure(l7PadRow(f pin layer kind)
  let((pad box w h)
    pad=axlDBGetPad(pin layer kind)
    box=if(pad then pad->bBox else nil)
    w=if(box then car(cadr(box))-car(car(box)) else nil)
    h=if(box then cadr(cadr(box))-cadr(car(box)) else nil)
    fprintf(f "%L\t%L\t%L\t%L\t%L\t%L\t%L\t%L\t%L\t%L\t%L\n"
      pin->name pin->number car(pin->xy) cadr(pin->xy) pin->rotation
      layer kind if(pad then pad->figureName else nil) w h box)))
procedure(l7Read(outDir)
  let((report pf df sf xf af pins pin ps pad layer kind layers xs polys poly bbox)
    report=outfile(strcat(outDir "/verify.txt"))
    pf=outfile(strcat(outDir "/pins.tsv"))
    df=outfile(strcat(outDir "/pads.tsv"))
    sf=outfile(strcat(outDir "/padstacks.tsv"))
    xf=outfile(strcat(outDir "/stackup.tsv"))
    af=outfile(strcat(outDir "/polygons.tsv"))
    unless(report && pf && df && sf && xf && af error("Cannot open readback files\n"))
    fprintf(report "L07_READ START\ndesign=%L type=%L units=%L\n" axlCurrentDesign() axlDesignType(t) axlDBGetDesignUnits())
    fprintf(report "stored_drcs=%d drc_state=%L\n" length(axlDBGetDesign()->drcs) axlDBGetDesign()->drcState)
    fprintf(pf "padstack\tnumber\tx\ty\trotation\tmechanical\tthrough\thole_type\tplating\tdrill_diameter\tdrill_x\tdrill_y\tstart_end\n")
    fprintf(df "padstack\tnumber\tx\ty\trotation\tlayer\tkind\tfigure\twidth\theight\tbbox\n")
    fprintf(sf "padstack\tusage\thole_type\tplating\tdrill_diameter\tdrill_x\tdrill_y\tdrill_offset\tthrough\tstart_end\tplating_api\n")
    fprintf(xf "name\tlayer_type\tmaterial\tthickness\tconductor\tnegative_artwork\n")
    fprintf(af "padstack\tnumber\tx\ty\trotation\tlayer\tindex\tbbox\tarea\tvertices\n")
    layers=list("ETCH/TOP" "ETCH/BOTTOM")
    foreach(xs axlXSectionGet(nil 'all)
      fprintf(xf "%L\t%L\t%L\t%L\t%L\t%L\n" xs->name xs->layerType xs->material xs->thickness xs->conductor xs->negativeArtwork)
      when(member(xs->name list("L2" "L3"))
        layers=append(layers list(strcat("ETCH/" xs->name)))))
    pins=l7AllPins()
    unless(length(pins)==6 error("Expected six pins\n"))
    foreach(ps axlDBGetDesign()->padstacks
      fprintf(sf "%L\t%L\t%L\t%L\t%L\t%L\t%L\t%L\t%L\t%L\t%L\n"
        ps->name ps->usage ps->holeType ps->plating ps->drillDiameter ps->drillSizeWidth ps->drillSizeHeight
        ps->drillOffset ps->isThrough ps->startEnd axlDBGetDrillPlating(ps->name)))
    foreach(pin pins
      ps=pin->definition
      fprintf(pf "%L\t%L\t%L\t%L\t%L\t%L\t%L\t%L\t%L\t%L\t%L\t%L\t%L\n"
        pin->name pin->number car(pin->xy) cadr(pin->xy) pin->rotation pin->isMech pin->isThrough
        ps->holeType ps->plating ps->drillDiameter ps->drillSizeWidth ps->drillSizeHeight pin->startEnd)
      foreach(layer layers
        foreach(kind list("REGULAR" "ANTI" "THERMAL" "KEEPOUT") l7PadRow(df pin layer kind))
        polys=axlPolyFromDB(pin ?layer layer ?padType 'REGULAR)
        foreach(poly polys
          fprintf(af "%L\t%L\t%L\t%L\t%L\t%L\t%d\t%L\t%L\t%L\n"
            pin->name pin->number car(pin->xy) cadr(pin->xy) pin->rotation layer 1 poly->bBox poly->area poly->vertices)))
      foreach(layer list("PIN/SOLDERMASK_TOP" "PIN/SOLDERMASK_BOTTOM" "PIN/PASTEMASK_TOP" "PIN/PASTEMASK_BOTTOM")
        l7PadRow(df pin layer "REGULAR"))
      foreach(kind list("REGULAR" "ANTI" "THERMAL" "KEEPOUT")
        pad=axlDBGetPad(ps 'internal kind)
        bbox=if(pad then pad->bBox else nil)
        fprintf(report "DEFAULT_INTERNAL padstack=%L kind=%L figure=%L bbox=%L\n"
          ps->name kind if(pad then pad->figureName else nil) bbox)))
    fprintf(report "pins=%d queried_etch_layers=%L\nL07_READ COMPLETE\n" length(pins) layers)
    foreach(f list(report pf df sf xf af) close(f))
    t))
