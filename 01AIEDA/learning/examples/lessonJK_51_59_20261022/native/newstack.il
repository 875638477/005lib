procedure(jkStackInvariant()
 let((rows p)
  rows=setof(r jk55Invariant() !(substring(r 1 7)=="COPPER " || substring(r 1 5)=="LINE " || substring(r 1 5)=="PSET " || substring(r 1 4)=="NET "))
  foreach(o jk55AllNetObjects()
   p=o->parent
   when(equal(o->objType "line") && o->isEtch && !o->thermal && !(p && p->thermal)
    rows=cons(sprintf(nil "FIXED_LINE %L" list(jk55Name(o) o->layer o->startEnd o->width)) rows)))
  foreach(s axlDBGetDesign()->symbols foreach(o s->children when(equal(o->objType "text") rows=cons(sprintf(nil "TEXT %L" list(s->refdes o->layer o->text o->xy o->rotation o->isMirrored o->justify o->textBlock)) rows))))
  sort(rows 'alphalessp)))
procedure(jkStackPlane(layer netname f)
 let((shapes graph netPins vias objects)
  shapes=setof(s axlDBGetShapes(layer) s->fill && !s->shapeIsBoundary && s->net && equal(s->net->name netname))
  unless(shapes error("New reference plane absent %s %s\n" layer netname))
  graph=gConnectedObjects(if(equal(netname "GND") then gPin("C1" "2") else gPin("C9" "1")))
  foreach(s shapes
   fprintf(f "PLANE %L %L connected=%L attrs=%L\n" layer netname if(member(s graph) then t else nil) s->??)
   unless(member(s graph) error("New plane has unconnected generated island %s\n" layer)))
  netPins=0 vias=0
  foreach(s axlDBGetDesign()->symbols foreach(p s->pins
   when(p->number && p->net && equal(p->net->name netname)
    unless(member(p graph) error("Real pin not in supply common %L %L\n" s->refdes p->number))
    fprintf(f "PIN_COMMON %L %L %L %L\n" netname s->refdes p->number p->xy) netPins=netPins+1)))
  foreach(o jk55AllNetObjects()
   when(equal(o->objType "via") && o->net && equal(o->net->name netname)
    unless(member(o graph) error("Real via not in supply common\n")) vias=vias+1))
  fprintf(f "PLANE_COMMON_SUMMARY layer=%L net=%L pins=%d vias=%d filledShapes=%d\n" layer netname netPins vias length(shapes))
  list(netPins vias)))
procedure(jkNewStack(out board)
 let((f mark result before after oldsets oldnet mother2 mother3 quiet poly new2 new3 newset newnet value expected p oldAnchor anchorFound submark response graph drc)
  f=outfile(strcat(out "/newstack_guard.txt")) jk55Audit=f
  before=jkStackInvariant() foreach(r before fprintf(f "BEFORE %s\n" r)) drain(f)
  oldsets=mapcar(lambda((c) list(c mapcar(lambda((l) list(l axlCNSGetPhysical(c l nil))) axlSubclassRoute()))) axlCnsList('physical))
  oldnet=mapcar(lambda((n) list(n->name axlDBGetProperties(n))) axlDBGetDesign()->nets)
  mark=axlDBTransactionStart() unless(mark error("New-stack transaction start failed\n"))
  result=errset(progn(
   mother2=setof(s axlDBGetShapes("BOUNDARY/L2") s->shapeIsBoundary && equal(jk55Name(s) "GND"))
   mother3=setof(s axlDBGetShapes("BOUNDARY/L3") s->shapeIsBoundary && equal(jk55Name(s) "GND"))
   quiet=setof(s axlDBGetShapes("ETCH/L2") s->fill && !s->shapeBoundary && !s->shapeIsBoundary && equal(jk55Name(s) "GND"))
   unless(length(mother2)==1 && length(mother3)==1 && length(quiet)==1 error("Legacy plane objects not uniquely identified\n"))
   foreach(s append(append(mother2 mother3) quiet)
    foreach(p axlPolyFromDB(s) fprintf(f "RETIRED_REAL_PLANE layer=%L net=%L area=%L vertices=%L holes=%L attrs=%L\n" s->layer jk55Name(s) p->area p->vertices mapcar(lambda((h) h->vertices) p->holes) s->??))) drain(f)
   poly=car(axlPolyFromDB(car(mother2)))
   unless(axlDeleteObject(car(quiet)) && axlDeleteObject(car(mother2)) && axlDeleteObject(car(mother3)) error("Legacy real planes not deleted\n"))
   unless(null(axlDBGetShapes("ETCH/L2")) && null(axlDBGetShapes("ETCH/L3")) error("Legacy inner ETCH shape remains\n"))
   newset="JK_P_V3V3_L3_PLANE"
   unless(axlCNSCreate('physical newset "P_POWER_060") error("Cannot clone real V3 physical set\n"))
   unless(axlCNSSetPhysical(newset "L3" 'allow_etch t) error("Cannot permit intended V3 L3 plane\n"))
   foreach(l axlSubclassRoute()
    expected=axlCNSGetPhysical("P_POWER_060" l nil)
    when(equal(l "L3") expected=subst(list('allow_etch t) assoc('allow_etch expected) expected))
    unless(equal(expected axlCNSGetPhysical(newset l nil)) error("V3 plane copy has unintended field differences\n")))
   newnet=axlDBFindByName('net "V3V3")
   unless(axlDBAddProp(list(newnet) list(list("PHYSICAL_CONSTRAINT_SET" newset))) error("Cannot bind V3-only plane set\n"))
   foreach(row oldsets foreach(l cadr(row) unless(equal(cadr(l) axlCNSGetPhysical(car(row) car(l) nil)) error("Original physical constraint field altered\n"))))
   foreach(row oldnet
    value=axlDBGetProperties(axlDBFindByName('net car(row)))
    if(equal(car(row) "V3V3") then
     value=setof(pr value !equal(car(pr) 'PHYSICAL_CONSTRAINT_SET))
     unless(equal(value cadr(row)) error("Unexpected V3 property difference\n"))
    else unless(equal(value cadr(row)) error("Other net props changed\n"))))
   new2=car(axlDBCreateShape(poly t "ETCH/L2" "GND" nil))
   unless(new2 error("Continuous L2 static source create failed\n"))
   new2=axlShapeChangeDynamicType(new2 t t)
   unless(new2 error("L2 dynamic conversion failed\n"))
   new3=car(axlDBCreateShape(poly t "ETCH/L3" "V3V3" nil))
   unless(new3 error("V3 L3 static source create failed\n"))
   new3=axlShapeChangeDynamicType(new3 t t)
   unless(new3 error("L3 dynamic conversion failed\n"))
   unless(equal(axlShapeDynamicUpdate(nil t) 0) && equal(axlDBDynamicShapes(nil) 0) error("Actual new plane fill not current\n"))
   fprintf(f "NEW_REAL_L2_BOUNDARY=%L\nNEW_REAL_L3_BOUNDARY=%L\n" new2->?? new3->??) drain(f)
   unless(null(setof(s axlDBGetShapes("ETCH/L3") equal(jk55Name(s) "GND"))) error("Legacy L3 GND plane remains\n"))
   jkStackPlane("ETCH/L2" "GND" f) jkStackPlane("ETCH/L3" "V3V3" f)
   foreach(ref list("C9" "C11" "C12" "C13" "C14" "C15" "C16" "C17")
    graph=gConnectedObjects(gPin(ref "1"))
    unless(setof(s graph equal(s->objType "shape") && equal(s->layer "ETCH/L3") && equal(jk55Name(s) "V3V3")) error("Cap V3 terminal fails actual L3 reach %s\n" ref))
    graph=gConnectedObjects(gPin(ref "2"))
    unless(setof(s graph equal(s->objType "shape") && equal(s->layer "ETCH/L2") && equal(jk55Name(s) "GND")) error("Cap GND terminal fails actual L2 reach %s\n" ref))
    fprintf(f "REFERENCE_CAP_ACTUAL_PLANE_REACH %s.1=V3V3/L3 %s.2=GND/L2; connectivity not HF certification\n" ref ref)) drain(f)
   axlDBRefreshId(nil)
   fprintf(f "ANCHOR_CANDIDATE_ALL_VIAS=%L\n" mapcar(lambda((v) list(v->xy jk55Name(v))) setof(v jk55AllNetObjects() equal(v->objType "via")))) drain(f)
   anchorFound=setof(o jk55AllNetObjects() equal(o->objType "via") && jk55Equal(o->xy list(46.35 29.4)) && equal(jk55Name(o) "GND"))
   unless(length(anchorFound)==1 error("Old anchor via not unique\n"))
   submark=axlDBTransactionStart()
   unless(axlDeleteObject(car(anchorFound)) error("Anchor challenge delete failed\n"))
   unless(equal(axlShapeDynamicUpdate(nil t) 0) error("Challenge fill failed\n"))
   graph=gConnectedObjects(gPin("C1" "2"))
   unless(member(gPin("C22" "2") graph) && member(gPin("C23" "2") graph) error("New continuous-L2 architecture unexpectedly lost HSE common after old anchor deletion\n"))
   fprintf(f "NEW_HSE_ANCHOR_REMOVAL_EXPECTS_STILL_COMMON actualC22=t actualC23=t\n") drain(f)
   axlDBTransactionRollback(submark)
   unless(equal(axlShapeDynamicUpdate(nil t) 0) error("Anchor rollback fill failed\n"))
   after=jkStackInvariant() foreach(r after fprintf(f "AFTER %s\n" r))
   unless(equal(before after) error("Manual copper/pads/vias/placements/Film invariant changed\n"))
   fprintf(f "FIXED_OBJECT_INVARIANT_IDENTICAL %d\n" length(before)) drain(f)
   hiStoredReadback()
   jk55ReadAll(out)
   foreach(netname list("GND" "V3V3")
    fprintf(f "SCOPED_BEGIN %s\n" netname) drain(f)
    drc=axlDRCItem(nil axlDBFindByName('net netname))
    fprintf(f "SCOPED_RESULT %s %L\n" netname drc) drain(f)
    unless(numberp(drc) && drc==0 error("New planes scoped DRC failed %s\n" netname)))
   fprintf(f "NEW_STACK_PRE_SAVE_PHYSICAL_CHECKS_COMPLETE WHOLE_DRC=null USB4=pending REMAINING_GPIO=7\n") drain(f)
   t) t)
  if(result then
   axlDBTransactionCommit(mark)
   unless(axlSaveDesign(?design board ?noMru t ?noConfirm t) error("New-stack SaveAs failed\n"))
   fprintf(f "NEW_STACK_SAVED_NEW_TRAINING_BOARD %s\n" board)
  else axlDBTransactionRollback(mark) fprintf(f "NEW_STACK_FAILED_ROLLBACK_NO_SAVE\n"))
  close(f) result))
