procedure(jk55AllNetObjects()
 let((objects)
  objects=nil
  foreach(n axlDBGetDesign()->nets foreach(b n->branches foreach(c b->children foreach(o gConnectedObjects(c) unless(member(o objects) objects=cons(o objects))))))
  foreach(b axlDBGetLonelyBranches() foreach(c b->children foreach(o gConnectedObjects(c) unless(member(o objects) objects=cons(o objects)))))
  objects))
procedure(jk55Name(o) if(o && o->net then o->net->name else nil))
procedure(jk55Invariant()
 let((rows d o p poly seen props)
  d=axlDBGetDesign() rows=nil
  fprintf(jk55Audit "SIGNATURE_COMP\n") drain(jk55Audit)
  foreach(c d->components
   rows=cons(sprintf(nil "COMP %L" list(c->name c->package c->deviceType axlDBGetProperties(c))) rows))
  fprintf(jk55Audit "SIGNATURE_SYMBOLS\n") drain(jk55Audit)
  foreach(s d->symbols
   rows=cons(sprintf(nil "POSE %L" list(s->refdes s->name s->xy s->rotation s->isMirrored axlDBGetProperties(s))) rows)
   foreach(p s->pins
    rows=cons(sprintf(nil "PIN %L" list(s->refdes p->number p->xy p->rotation p->name p->isMech jk55Name(p))) rows)
    foreach(l append(mapcar(lambda((x) strcat("ETCH/" x)) axlSubclassRoute()) list("PIN/SOLDERMASK_TOP" "PIN/SOLDERMASK_BOTTOM" "PIN/PASTEMASK_TOP" "PIN/PASTEMASK_BOTTOM"))
     o=axlDBGetPad(p l "REGULAR")
     rows=cons(sprintf(nil "PAD %L" list(s->refdes p->number l if(o then o->figureName else nil) if(o then o->bBox else nil))) rows)))
   foreach(o s->children
    unless(equal(o->objType "text")
     props=axlDBGetProperties(o)
     when(equal(o->layer "PACKAGE GEOMETRY/PLACE_BOUND_TOP") props=setof(pr props !equal(upperCase(sprintf(nil "%s" car(pr))) "PACKAGE_HEIGHT_MAX")))
     poly=if(equal(o->objType "shape") then car(axlPolyFromDB(o)) else nil)
     rows=cons(sprintf(nil "CHILD %L" list(s->refdes o->objType o->layer o->bBox props if(poly then poly->vertices else nil) if(poly then mapcar(lambda((h) h->vertices) poly->holes) else nil))) rows))))
  fprintf(jk55Audit "SIGNATURE_SYMDEFS\n") drain(jk55Audit)
  foreach(s d->symdefs
   foreach(o s->children
    poly=if(equal(o->objType "shape") then car(axlPolyFromDB(o)) else nil)
    rows=cons(sprintf(nil "SYMDEF %L" list(s->name o->objType o->layer o->bBox axlDBGetProperties(o) if(poly then poly->vertices else nil) if(equal(o->objType "text") then list(o->text o->xy o->rotation o->textBlock) else nil))) rows)))
  fprintf(jk55Audit "SIGNATURE_EXTRACT\n") drain(jk55Audit)
  seen=nil
  foreach(o jk55AllNetObjects()
   unless(member(o seen)
    seen=cons(o seen)
    when(equal(o->objType "line") && o->isEtch
     rows=cons(sprintf(nil "LINE %L" list(jk55Name(o) o->layer o->startEnd o->width o->isEtch o->thermal)) rows))
    when(equal(o->objType "via")
     rows=cons(sprintf(nil "VIA %L" list(jk55Name(o) o->name o->xy o->definition->usage o->definition->drillDiameter axlDBGetProperties(o))) rows)
     foreach(l axlSubclassRoute()
      p=axlDBGetPad(o strcat("ETCH/" l) "REGULAR")
      rows=cons(sprintf(nil "VIAPAD %L" list(o->xy l if(p then p->figureName else nil) if(p then p->bBox else nil))) rows)))))
  fprintf(jk55Audit "SIGNATURE_SHAPES\n") drain(jk55Audit)
  foreach(o axlDBGetShapes("ETCH")
   foreach(poly axlPolyFromDB(o)
    rows=cons(sprintf(nil "COPPER %L" list(o->layer jk55Name(o) o->fill o->shapeIsBoundary o->fillOOD o->bBox poly->area poly->vertices mapcar(lambda((h) h->vertices) poly->holes) axlDBGetProperties(o))) rows)))
  fprintf(jk55Audit "SIGNATURE_RULES\n") drain(jk55Audit)
  foreach(n axlGetParam("artwork")->groupMembers rows=cons(sprintf(nil "FILM %L %L" n axlGetParam(strcat("artwork:" n))->??) rows))
  foreach(xs axlXSectionGet(nil 'all) rows=cons(sprintf(nil "XS %L" xs->??) rows))
  foreach(n d->nets rows=cons(sprintf(nil "NET %L" list(n->name axlDBGetProperties(n) axlNetClassGet(n 'physical t) axlNetClassGet(n 'spacing t) axlNetClassGet(n 'electrical t))) rows))
  foreach(c axlCnsList('physical) foreach(l axlSubclassRoute() rows=cons(sprintf(nil "PSET %L" list(c l axlCNSGetPhysical(c l nil))) rows)))
  foreach(c axlCnsList('spacing) foreach(l axlSubclassRoute() rows=cons(sprintf(nil "SSET %L" list(c l axlCNSGetSpacing(c l nil))) rows)))
  foreach(c axlCnsList('electrical) rows=cons(sprintf(nil "ESET %L" list(c axlCNSEcsetValueGet(c 'all t))) rows))
  foreach(c axlCnsClassTableFind('netclass) rows=cons(sprintf(nil "TABLE %L" list(c axlDBGetProperties(c) c->physical c->spacing c->sameNet c->assembly if(c->region then c->region->name else nil) if(c->netclass1 then c->netclass1->name else nil) if(c->netclass2 then c->netclass2->name else nil))) rows))
  rows=cons(sprintf(nil "MODES %L" list(axlDBControl('drcEnable) axlCNSPhysicalModeGet('all) axlCNSSpacingModeGet('all) axlCNSEcsetModeGet('all))) rows)
  rows=cons(sprintf(nil "MECHANICS %L" list(d->designOutline d->keepinRoute d->keepinPlace d->keepouts)) rows)
  sort(rows 'alphalessp)))
procedure(jk55ExtendedRead(out)
 let((f d)
  f=outfile(strcat(out "/jk55_instance_properties.tsv")) d=axlDBGetDesign()
  foreach(c d->components fprintf(f "COMP\t%L\t%L\t%L\t%L\n" c->name c->package c->deviceType axlDBGetProperties(c)))
  foreach(s d->symbols
   fprintf(f "SYMBOL\t%L\t%L\t%L\t%L\t%L\n" s->refdes s->definition->name s->xy s->rotation axlDBGetProperties(s))
   foreach(o s->children when(equal(o->layer "PACKAGE GEOMETRY/PLACE_BOUND_TOP") fprintf(f "BOUND\t%L\t%L\t%L\t%L\t%L\n" s->refdes o->objType o->bBox axlDBGetProperties(o) o))))
  close(f)
  jk56Probe(strcat(out "/jk56_parameters.tsv")) t))
procedure(jk55ReadAll(out)
 fcorRead(out) fcorOutline(out) jkSnapshot(out nil) hiNetworkInventory(out)
 hiExtraRead(out) hiShapeBoundaryRead(out) hiRouteRoles(out) hiUSBMaskRead(out)
 hiBranchAudit(out) hiMechanicalPinRead(out) hiReferenceCoverageRead(out 0.1)
 jk55ExtendedRead(out) t)
procedure(jk55Run(variant out board)
 let((f mark before after ok result)
  f=outfile(strcat(out "/jk55_guard.txt"))
  jk55Audit=f
  before=jk55Invariant() foreach(row before fprintf(f "BEFORE %s\n" row)) drain(f)
  mark=axlDBTransactionStart() unless(mark error("JK55 transaction cannot begin\n"))
  result=errset(progn(
   jk55Apply(variant strcat(out "/jk55_apply.txt"))
   after=jk55Invariant() foreach(row after fprintf(f "AFTER %s\n" row)) drain(f)
   unless(equal(before after) error("JK55 invariant differs; refuse save\n"))
   fprintf(f "INVARIANT_IDENTICAL count=%d\n" length(before)) drain(f)
   hiStoredReadback()
   jk55ReadAll(out)
   t) t)
  if(result then
   axlDBTransactionCommit(mark)
   unless(axlSaveDesign(?design board ?noMru t ?noConfirm t) error("JK55 SaveAs new output failed\n"))
   fprintf(f "JK55_BUILD_SAVED_NEW_OUTPUT %s\n" board) drain(f)
  else
   axlDBTransactionRollback(mark)
   fprintf(f "JK55_FAILED_ROLLED_BACK_NO_SAVE\n") drain(f))
  close(f) result))
