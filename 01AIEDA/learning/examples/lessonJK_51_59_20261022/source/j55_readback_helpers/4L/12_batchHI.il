hiRegistry=nil
procedure(hiReg(id kind obj)
 when(assoc(id hiRegistry) error("Duplicate operation id %s\n" id))
 hiRegistry=cons(list(id kind obj) hiRegistry) obj)
procedure(hiResolve(key)
 let((parts row obj)
  parts=parseString(key ".")
  if(length(parts)==2 then
   obj=gPin(car(parts) cadr(parts))
  else
   row=assoc(key hiRegistry)
   unless(row error("Unknown endpoint %s\n" key))
   obj=caddr(row)
   when(listp(obj) obj=car(obj)))
  obj))
procedure(hiProof(f from to expected)
 let((a b graph reached)
  a=hiResolve(from) b=hiResolve(to)
  graph=gConnectedObjects(a)
  reached=if(member(b graph) then t else nil)
  fprintf(f "HI_ENDPOINT_PROOF from=%L to=%L expected=%L actual=%L objects=%d\n" from to expected reached length(graph))
  unless(equal(reached expected) error("Native endpoint proof failed %s -> %s\n" from to))
  t))
procedure(hiMove(f ref xy angle)
 let((s delta result before)
  s=gComponent(ref)->symbol before=list(s->xy s->rotation s->isMirrored)
  delta=list(car(xy)-car(s->xy) cadr(xy)-cadr(s->xy))
  unless(equal(delta list(0.0 0.0)) unless(axlTransformObject(s ?move delta) error("Placement move failed\n")))
  axlDBRefreshId(nil) s=gComponent(ref)->symbol
  unless(equal(s->rotation angle) unless(axlTransformObject(s ?angle angle-s->rotation) error("Placement rotate failed\n")))
  axlDBRefreshId(nil) s=gComponent(ref)->symbol
  fprintf(f "HI_PLACEMENT %L before=%L actual=%L\n" ref before list(s->xy s->rotation s->isMirrored))
  unless(equal(s->xy xy) && equal(s->rotation angle) error("Placement not as planned\n"))
  t))
procedure(hiCSet(f domain name copy values)
 unless(axlCNSCreate(domain name copy) error("Cannot create explicit CSet %s\n" name))
 foreach(row values
  if(equal(domain 'physical) then
   unless(axlCNSSetPhysical(name nil car(row) cadr(row)) error("Cannot set physical CSet\n"))
  else
   unless(axlCNSSetSpacing(name nil car(row) cadr(row)) error("Cannot set spacing CSet\n"))))
 fprintf(f "HI_CSET_COPY domain=%L name=%L copyTemplate=%L changes=%L\n" domain name copy values)
 t)
procedure(hiClosedPath(points)
 let((p q)
  q=points
  unless(equal(car(points) car(last(points))) q=append(points list(car(points))))
  p=axlPathStart(q 0.0)
  unless(p error("Cannot create closed polygon path\n")) p))
procedure(hiRegion(f id layer polygon assignments)
 let((region shape tbl)
  region=axlRegionCreate(id)
  unless(region error("Cannot create region %s\n" id))
  shape=car(axlDBCreateShape(hiClosedPath(polygon) nil strcat("CONSTRAINT REGION/" layer)))
  unless(shape && axlRegionAdd(region shape) error("Cannot create actual region polygon\n"))
  foreach(a assignments
   tbl=axlCnsClassTableCreate(car(a) nil region cadr(a) caddr(a))
   unless(tbl error("Cannot assign Region-Class rule\n"))
   fprintf(f "HI_REGION_CLASS region=%L class=%L domain=%L cset=%L table=%L\n" id car(a) cadr(a) caddr(a) tbl->??))
  fprintf(f "HI_REGION_GEOMETRY %L\n" shape->??)
  axlCNSMapUpdate()
  t))
procedure(hiVia(f id net xy padstack)
 let((ret)
  ret=axlDBCreateVia(padstack xy net nil 0.0 nil)
  fprintf(f "HI_VIA id=%L net=%L xy=%L padstack=%L result=%L\n" id net xy padstack ret)
  unless(ret error("Via creation failed\n"))
  hiReg(id "via" car(ret)) car(ret)))
procedure(hiRoute(f id net layer points widths)
 let((ret)
  ret=gRouteNative(net points widths strcat("ETCH/" layer) f id)
  hiReg(id "route" car(ret))
  ret))
procedure(hiFinalize(f out board lib proofs)
 let((count)
  unless(equal(axlShapeDynamicUpdate(nil t) 0) error("Actual shape update failed\n"))
  axlDBRefreshId(nil)
  axlDRCUpdate(t) f29DumpDRC(f "HI_BATCH_FINAL")
  count=length(axlDBGetDesign()->drcs)
  foreach(p proofs hiProof(f car(p) cadr(p) caddr(p)))
  unless(axlSaveDesign(?design board ?noMru t ?noConfirm t) error("Cannot save HI candidate checkpoint\n"))
  fprintf(f "HI_BATCH_COMPLETED drcCount=%d status=%s board=%L\n" count if(count==0 then "CANDIDATE_DRC_ZERO_NOT_ENGINEERING_RELEASE" else "CANDIDATE_FAILED_DRC") board)
  close(f)
  gSnapshot(out lib)
  hiNetworkInventory(out)
  t))
