axlVisibleDesign(nil)
axlVisibleLayer("ETCH/TOP" t)
axlVisibleLayer("ETCH/BOTTOM" t)
axlVisibleLayer("PIN/TOP" t)
axlVisibleLayer("PIN/BOTTOM" t)
axlVisibleLayer("VIA CLASS/TOP" t)
axlVisibleLayer("VIA CLASS/BOTTOM" t)
axlVisibleLayer("PACKAGE GEOMETRY/ASSEMBLY_TOP" t)
axlVisibleLayer("REF DES/ASSEMBLY_TOP" t)
axlVisibleLayer("BOARD GEOMETRY/DESIGN_OUTLINE" t)
axlVisibleUpdate(nil)
axlWindowBoxSet(list(-148:-39 -59:9.5))
axlUIWUpdate(nil)
AI_vf=outfile("D:/001DIY/023USB/08UsbIPDapLink/02pcb/compact_layout/preview_ready.txt")
fprintf(AI_vf "Opened final compact placement; 237 symbols.\n")
close(AI_vf)
