; Isolate one copper layer: ETCH + PIN + VIA CLASS + DRC together.
; Layer names follow drill*.txt: TOP / L2..L17 / BOTTOM.
; Never sprintf("%s") a visibility object  axlVisibleGet returns structs.

procedure(IsoEtchKnownNames()
    list("TOP" "L2" "L3" "L4" "L5" "L6" "L7" "L8" "L9"
        "L10" "L11" "L12" "L13" "L14" "L15" "L16" "L17" "BOTTOM")
)

procedure(IsoEtchSafeStr(x)
    cond(
        (null(x) "")
        (stringp(x) x)
        (symbolp(x) pname(x))
        (numberp(x) sprintf(nil "%L" x))
        (t "")
    )
)

procedure(IsoEtchField(obj field)
    let((ret)
        ret = errset(get(obj field))
        if(and(ret car(ret)) then IsoEtchSafeStr(car(ret)) else "")
    )
)

procedure(IsoEtchSameName(a b)
    let((sa sb)
        sa = upperCase(IsoEtchSafeStr(a))
        sb = upperCase(IsoEtchSafeStr(b))
        and(greaterp(strlen(sa) 0) greaterp(strlen(sb) 0) equal(sa sb))
    )
)

procedure(IsoEtchIsConductor(subName)
    let((found)
        found = nil
        foreach(name IsoEtchKnownNames()
            when(IsoEtchSameName(name subName)
                found = t
            )
        )
        found
    )
)

procedure(IsoEtchSetVisible(layerName on)
    let((ret name)
        name = IsoEtchSafeStr(layerName)
        if(lessp(strlen(name) 1) then
            nil
        else
            ret = errset(axlVisibleLayer(name on))
            and(ret car(ret))
        )
    )
)

procedure(IsoEtchApply(subName on)
    let((etchOn)
        etchOn = IsoEtchSetVisible(sprintf(nil "ETCH/%s" subName) on)
        IsoEtchSetVisible(sprintf(nil "PIN/%s" subName) on)
        IsoEtchSetVisible(sprintf(nil "VIA CLASS/%s" subName) on)
        IsoEtchSetVisible(sprintf(nil "VIA/%s" subName) on)
        IsoEtchSetVisible(sprintf(nil "DRC ERROR CLASS/%s" subName) on)
        IsoEtchSetVisible(sprintf(nil "DRC/%s" subName) on)
        etchOn
    )
)

procedure(IsoEtchFullName(lyr)
    prog((cls sub name)
        when(stringp(lyr) return(lyr))
        name = IsoEtchField(lyr 'name)
        when(greaterp(strlen(name) 0) return(name))
        cls = IsoEtchField(lyr 'class)
        sub = IsoEtchField(lyr 'subclass)
        when(and(greaterp(strlen(cls) 0) greaterp(strlen(sub) 0))
            return(sprintf(nil "%s/%s" cls sub))
        )
        when(and(listp(lyr) stringp(car(lyr)) cdr(lyr) stringp(cadr(lyr)))
            return(sprintf(nil "%s/%s" car(lyr) cadr(lyr)))
        )
        return("")
    )
)

procedure(IsoEtchLayerClass(lyr)
    prog((cls parts)
        cls = IsoEtchField(lyr 'class)
        when(greaterp(strlen(cls) 0) return(cls))
        parts = parseString(IsoEtchFullName(lyr) "/")
        when(parts return(car(parts)))
        return("")
    )
)

procedure(IsoEtchLayerSub(lyr)
    prog((sub parts)
        sub = IsoEtchField(lyr 'subclass)
        when(greaterp(strlen(sub) 0) return(sub))
        parts = parseString(IsoEtchFullName(lyr) "/")
        when(and(parts cdr(parts)) return(cadr(parts)))
        return("")
    )
)

procedure(IsoEtchTrackedClass(cls)
    or(
        equal(cls "ETCH")
        equal(cls "PIN")
        equal(cls "VIA CLASS")
        equal(cls "VIA")
        equal(cls "DRC ERROR CLASS")
        equal(cls "DRC")
    )
)

procedure(IsoEtchIsThroughAll(sub)
    let((s)
        s = upperCase(IsoEtchSafeStr(sub))
        unless(greaterp(strlen(s) 0) nil)
        or(
            rexMatchp("THROUGH" s)
            rexMatchp("THRU" s)
        )
    )
)

procedure(IsoEtchClassSubs(cls)
    prog((ret)
        ret = errset(axlSubclasses(cls))
        when(and(ret car(ret)) return(car(ret)))
        ret = errset(axlGetParam(sprintf(nil "paramLayerGroup:%s" cls)))
        when(and(ret car(ret) get(car(ret) 'groupMembers))
            return(car(ret)->groupMembers)
        )
        return(nil)
    )
)

; Color-dialog All Off / All On. Visibility pane "View" clicks are not a stable command.
procedure(IsoEtchAllVisible(on)
    let((ret)
        ret = errset(axlVisibleDesign(on))
        and(ret car(ret))
    )
)

procedure(IsoEtchHideKnown(keepSub)
    let((name)
        foreach(name IsoEtchKnownNames()
            unless(IsoEtchSameName(name keepSub)
                IsoEtchApply(name nil)
            )
        )
    )
)

procedure(IsoEtchHideOtherVisible(keepSub)
    let((ret lyr cls sub full)
        ret = errset(axlVisibleGet())
        when(and(ret car(ret))
            foreach(lyr car(ret)
                errset(
                    progn(
                        cls = IsoEtchLayerClass(lyr)
                        sub = IsoEtchLayerSub(lyr)
                        full = IsoEtchFullName(lyr)
                        when(and(
                            IsoEtchTrackedClass(cls)
                            IsoEtchIsConductor(sub)
                            greaterp(strlen(full) 0))
                            unless(IsoEtchSameName(sub keepSub)
                                IsoEtchSetVisible(full nil)
                            )
                        )
                    )
                )
            )
        )
    )
)

procedure(IsoEtchShowDrcAll()
    t
)

procedure(IsoEtchHideThroughAll()
    let((cls sub full ret lyr classes)
        foreach(name list(
            "PIN/THROUGH_ALL" "PIN/THROUGH ALL" "PIN/Through All"
            "VIA CLASS/THROUGH_ALL" "VIA CLASS/THROUGH ALL" "VIA CLASS/Through All"
            "VIA/THROUGH_ALL" "VIA/THROUGH ALL"
            "ETCH/THROUGH_ALL" "ETCH/THROUGH ALL"
            "DRC ERROR CLASS/THROUGH_ALL" "DRC ERROR CLASS/THROUGH ALL"
            "DRC/THROUGH_ALL")
            IsoEtchSetVisible(name nil)
        )
        foreach(cls list("PIN" "VIA CLASS" "VIA" "ETCH" "DRC ERROR CLASS" "DRC")
            foreach(sub IsoEtchClassSubs(cls)
                when(IsoEtchIsThroughAll(sub)
                    IsoEtchSetVisible(sprintf(nil "%s/%s" cls IsoEtchSafeStr(sub)) nil)
                )
            )
        )
        classes = errset(axlGetParam("paramLayerGroup")->groupMembers)
        when(and(classes car(classes))
            foreach(cls car(classes)
                foreach(sub IsoEtchClassSubs(cls)
                    when(IsoEtchIsThroughAll(sub)
                        IsoEtchSetVisible(sprintf(nil "%s/%s" IsoEtchSafeStr(cls) IsoEtchSafeStr(sub)) nil)
                    )
                )
            )
        )
        ret = errset(axlVisibleGet())
        when(and(ret car(ret))
            foreach(lyr car(ret)
                errset(
                    progn(
                        cls = IsoEtchLayerClass(lyr)
                        sub = IsoEtchLayerSub(lyr)
                        full = IsoEtchFullName(lyr)
                        when(and(IsoEtchIsThroughAll(sub) greaterp(strlen(full) 0))
                            IsoEtchSetVisible(full nil)
                        )
                    )
                )
            )
        )
        errset(axlFlushDisplay())
    )
)

procedure(IsoEtchFinish(msg)
    errset(IsoEtchHideThroughAll())
    errset(axlVisibleUpdate(t))
    printf("%s\n" IsoEtchSafeStr(msg))
)

procedure(IsoEtchByName(subName)
    prog((name etchOn)
        unless(subName
            printf("IsoEtchByName: empty layer name\n")
            return()
        )
        errset(IsoEtchHideThroughAll())
        if(IsoEtchSameName(subName "ALL") then
            unless(IsoEtchAllVisible(t)
                foreach(name IsoEtchKnownNames()
                    IsoEtchApply(name t)
                )
            )
            IsoEtchShowDrcAll()
            IsoEtchSetVisible("BOARD GEOMETRY/OUTLINE" t)
            IsoEtchFinish("Show all layers; Through All stays off")
            return()
        )
        ; Close every class first, then open only this layer's stack.
        unless(IsoEtchAllVisible(nil)
            IsoEtchHideKnown(subName)
            errset(IsoEtchHideOtherVisible(subName))
        )
        etchOn = IsoEtchApply(subName t)
        IsoEtchShowDrcAll()
        IsoEtchSetVisible("BOARD GEOMETRY/OUTLINE" t)
        unless(etchOn
            IsoEtchFinish(sprintf(nil "IsoEtchByName: this board has no ETCH/%s" subName))
            return()
        )
        errset(axlShell(sprintf(nil "subclass %s" subName)))
        IsoEtchFinish(sprintf(nil "Isolate %s (ETCH/PIN/VIA/DRC)" subName))
    )
)

procedure(IsoEtchLayer(n)
    cond(
        (n == 0 IsoEtchByName("ALL"))
        (n == 1 IsoEtchByName("TOP"))
        (t IsoEtchByName(sprintf(nil "L%d" n)))
    )
)
